nlind_tran: ngspice twin of testdata/netlists/nlind_tran.cir
* columns: v(a) i(ln)
* ngspice has no flux-defined inductor; its dual is built with a gyrator:
* H1 makes V(w) equal the inductor current i, the Q-capacitor there holds
* charge λ(i, t), so its current is dλ/dt, and H2 sets the branch voltage
* to that current: v = dλ/dt.
V1 in 0 SIN(0 5 1k)
R1 in a 20
Vs a m 0
H2 m 0 Vw 1
H1 w 0 Vs 1
Vw w w2 0
CL w2 0 Q='pwl(time, 0,1, 1e-3,1.5, 2e-3,1.2, 10,1.2)*pwl(V(w2), -10,-1.2e-3, -0.1,-0.6e-3, -0.05,-0.4e-3, 0,0, 0.05,0.4e-3, 0.1,0.6e-3, 10,1.2e-3)'
.options reltol=1e-6 abstol=1e-15 vntol=1e-9
.control
tran 5u 3m 0 20n
linearize
wrdata out.txt v(a) i(vs)
.endc
.end
