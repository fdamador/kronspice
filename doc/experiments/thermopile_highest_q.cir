Bi-Al thermopile element with bifilar coil, highest-Q design (kronspice examples/bial_bifilar)
*
* Coil (bifilar): 11 turns, diameter 20.41 mm, wire 1.703 mm, pitch 2.236 mm, insulation eps 6, copper
*   Lcoil  = 1.469 uH   Wheeler (Proc. IRE 1928)
*   Cself  = 34.66 pF   turn-to-turn capacitance, V/2 per gap (bifilar, Tesla US 512,340)
*   Rcoil  = 156.2 mOhm   copper, skin effect at f0
* Bi-Al element: plates 19.64 mm square, gap 1.941 mm
*   Vbial  = 22.65 mV   Seebeck EMF 3 x (S_Al - S_Bi)*dT = 3 x 75.5 uV/K * 100 K; energy from HEAT (thermal port)
*   Rint   = 54.44 mOhm   6 Bi and Al legs (562.3 um dia. x 3.34 mm) plus plates; legs conduct 5.463 W of heat at dT
*   Cplate = 3.889 pF   plates with dielectric eps 2.21, in series with the EMF (DC is blocked)
* Iprobe: 1 A AC current into node a (DC 0), so vm(a) = |Z| of the tank in the .ac run.
* Vbial switches on at t = 0 (PWL; an idealized step - a real thermal or chemical source is slower).
* Simulated: f0 = 21.15 MHz, Q = 1245, stored energy at steady state 997.6 aJ (85.84 pJ/m^3 per volume).
* Note: SPICE itself books Vbial as an ordinary source; kronspice's ledger attributes its energy to the thermal port.
* ngspice: run, then  plot vm(a)  (ac)  or  plot v(a) i(Vbial)  (tran)
*
Rcoil a c 0.15615783442224507
Lcoil c 0 1.4686333940452032e-06
Cself a 0 3.466101379674565e-11
Rint a n1 0.05444497863045677
Vbial n1 n2 PWL(0 0 1e-12 0.02265)
Cplate n2 0 3.88894499548864e-12
Iprobe 0 a DC 0 AC 1 0
.ac dec 200 211520 2.1152e+09
.tran 1.18192e-09 9.45537e-05 0 1.18192e-09
.end
