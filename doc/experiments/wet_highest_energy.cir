Bi-Al wet element with bifilar coil, highest energy-per-volume design (kronspice examples/bial_bifilar)
*
* Coil (bifilar): 10 turns, diameter 5.035 mm, wire 782.4 um, pitch 821.5 um, insulation eps 4.63, copper
*   Lcoil  = 238.1 nH   Wheeler (Proc. IRE 1928)
*   Cself  = 14.56 pF   turn-to-turn capacitance, V/2 per gap (bifilar, Tesla US 512,340)
*   Rcoil  = 5.527 mOhm   copper, skin effect at f0
* Bi-Al element: plates 64.89 mm square, gap 50 um
*   Vbial  = 1.97 V   Al|electrolyte|Bi cell EMF (1 x standard 1.970 V); energy from CHEMISTRY (chemical port)
*   Relec  = 2.494 mOhm   electrolyte, rho 0.21 Ohm*m
*   Rct    = 475 mOhm   charge transfer, two electrodes (assumed 10 Ohm*cm2 each)
*   Cdl    = 421.1 uF   double layers, two in series (20 uF/cm2 each)
*   Cgeo   = 59.65 nF   geometric plate capacitance, water eps 80
* Iprobe: 1 A AC current into node a (DC 0), so vm(a) = |Z| of the tank in the .ac run.
* Vbial switches on at t = 0 (PWL; an idealized step - a real thermal or chemical source is slower).
* Simulated: f0 = 15.63 kHz, Q = 2.398, stored energy at steady state 792.1 uJ (89.29 J/m^3 per volume).
* Note: SPICE itself books Vbial as an ordinary source; kronspice's ledger attributes its energy to the chemical port.
* ngspice: run, then  plot vm(a)  (ac)  or  plot v(a) i(Vbial)  (tran)
*
Rcoil a c 0.005526851525161358
Lcoil c 0 2.3805396432549263e-07
Cself a 0 1.4560777379865457e-11
Relec a n1 0.002493699843516566
Vbial n1 n2 PWL(0 0 1e-12 1.97)
Rct n2 0 0.4749904463841078
Cdl n2 0 0.00042106110032846247
Cgeo a 0 5.96504650075589e-08
Iprobe 0 a DC 0 AC 1 0
.ac dec 200 156.322 1.56322e+06
.tran 1.59926e-06 0.00127941 0 1.59926e-06
.end
