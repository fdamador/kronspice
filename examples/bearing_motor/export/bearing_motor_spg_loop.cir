SPG loop with bearing motor
.domain mechanical w
VE0 e 0 DC 3.41
PB e x w 0 1e-05 KAPPA=2.7548232420067764e-06 W0=282.7433388230814
RLOOP x 0 0.00038864400917643246
VW w 0 DC 282.7433388230814
.op
.end
