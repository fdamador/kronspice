acoustic drive with bubble
.domain mechanical v
.domain acoustic p
VGEN g 0 DC 0 AC 1 0
RGEN g a 50
LMATCH a e 0.010111626690817235
RLMATCH e x 0.5
C0 x 0 4e-09
YPZT x 0 v 0 0.6
CMASS v 0 0.004
LSPRING v 0 1.0111626690817235e-08
RLOSS v 0 0.3333333333333333
YCOUPLE v 0 p 0 0.0002
CMODE p 0 7.650334663231506e-15
LMODE p 0 5286.893782262894
RMODE p 0 1.2469565900682e+12
RBUBBLE p 0 2.4256001468291934e+13
CBUBBLE p 0 1.7965425814236247e-19
.ac lin 4001 24900.192405000002 25150.445595000001
.end
