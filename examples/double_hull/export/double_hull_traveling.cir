double hull
L0 n0 m0 4.1534585187917715e-09
R0 m0 n1 0.00010450781339548083
C0 n0 0 2.926501447922784e-10
L1 n1 m1 4.1534585187917715e-09
R1 m1 n2 0.00010450781339548083
C1 n1 0 2.926501447922784e-10
L2 n2 m2 4.1534585187917715e-09
R2 m2 n3 0.00010450781339548083
C2 n2 0 2.926501447922784e-10
L3 n3 m3 4.1534585187917715e-09
R3 m3 n4 0.00010450781339548083
C3 n3 0 2.926501447922784e-10
L4 n4 m4 4.1534585187917715e-09
R4 m4 n5 0.00010450781339548083
C4 n4 0 2.926501447922784e-10
L5 n5 m5 4.1534585187917715e-09
R5 m5 n6 0.00010450781339548083
C5 n5 0 2.926501447922784e-10
L6 n6 m6 4.1534585187917715e-09
R6 m6 n7 0.00010450781339548083
C6 n6 0 2.926501447922784e-10
L7 n7 m7 4.1534585187917715e-09
R7 m7 n8 0.00010450781339548083
C7 n7 0 2.926501447922784e-10
L8 n8 m8 4.1534585187917715e-09
R8 m8 n9 0.00010450781339548083
C8 n8 0 2.926501447922784e-10
L9 n9 m9 4.1534585187917715e-09
R9 m9 n10 0.00010450781339548083
C9 n9 0 2.926501447922784e-10
L10 n10 m10 4.1534585187917715e-09
R10 m10 n11 0.00010450781339548083
C10 n10 0 2.926501447922784e-10
L11 n11 m11 4.1534585187917715e-09
R11 m11 n12 0.00010450781339548083
C11 n11 0 2.926501447922784e-10
L12 n12 m12 4.1534585187917715e-09
R12 m12 n13 0.00010450781339548083
C12 n12 0 2.926501447922784e-10
L13 n13 m13 4.1534585187917715e-09
R13 m13 n14 0.00010450781339548083
C13 n13 0 2.926501447922784e-10
L14 n14 m14 4.1534585187917715e-09
R14 m14 n15 0.00010450781339548083
C14 n14 0 2.926501447922784e-10
L15 n15 m15 4.1534585187917715e-09
R15 m15 n16 0.00010450781339548083
C15 n15 0 2.926501447922784e-10
L16 n16 m16 4.1534585187917715e-09
R16 m16 n17 0.00010450781339548083
C16 n16 0 2.926501447922784e-10
L17 n17 m17 4.1534585187917715e-09
R17 m17 n18 0.00010450781339548083
C17 n17 0 2.926501447922784e-10
L18 n18 m18 4.1534585187917715e-09
R18 m18 n19 0.00010450781339548083
C18 n18 0 2.926501447922784e-10
L19 n19 m19 4.1534585187917715e-09
R19 m19 n20 0.00010450781339548083
C19 n19 0 2.926501447922784e-10
L20 n20 m20 4.1534585187917715e-09
R20 m20 n21 0.00010450781339548083
C20 n20 0 2.926501447922784e-10
L21 n21 m21 4.1534585187917715e-09
R21 m21 n22 0.00010450781339548083
C21 n21 0 2.926501447922784e-10
L22 n22 m22 4.1534585187917715e-09
R22 m22 n23 0.00010450781339548083
C22 n22 0 2.926501447922784e-10
L23 n23 m23 4.1534585187917715e-09
R23 m23 n24 0.00010450781339548083
C23 n23 0 2.926501447922784e-10
L24 n24 m24 4.1534585187917715e-09
R24 m24 n25 0.00010450781339548083
C24 n24 0 2.926501447922784e-10
L25 n25 m25 4.1534585187917715e-09
R25 m25 n26 0.00010450781339548083
C25 n25 0 2.926501447922784e-10
L26 n26 m26 4.1534585187917715e-09
R26 m26 n27 0.00010450781339548083
C26 n26 0 2.926501447922784e-10
L27 n27 m27 4.1534585187917715e-09
R27 m27 n28 0.00010450781339548083
C27 n27 0 2.926501447922784e-10
L28 n28 m28 4.1534585187917715e-09
R28 m28 n29 0.00010450781339548083
C28 n28 0 2.926501447922784e-10
L29 n29 m29 4.1534585187917715e-09
R29 m29 n30 0.00010450781339548083
C29 n29 0 2.926501447922784e-10
L30 n30 m30 4.1534585187917715e-09
R30 m30 n31 0.00010450781339548083
C30 n30 0 2.926501447922784e-10
L31 n31 m31 4.1534585187917715e-09
R31 m31 n32 0.00010450781339548083
C31 n31 0 2.926501447922784e-10
L32 n32 m32 4.1534585187917715e-09
R32 m32 n33 0.00010450781339548083
C32 n32 0 2.926501447922784e-10
L33 n33 m33 4.1534585187917715e-09
R33 m33 n34 0.00010450781339548083
C33 n33 0 2.926501447922784e-10
L34 n34 m34 4.1534585187917715e-09
R34 m34 n35 0.00010450781339548083
C34 n34 0 2.926501447922784e-10
L35 n35 m35 4.1534585187917715e-09
R35 m35 n36 0.00010450781339548083
C35 n35 0 2.926501447922784e-10
L36 n36 m36 4.1534585187917715e-09
R36 m36 n37 0.00010450781339548083
C36 n36 0 2.926501447922784e-10
L37 n37 m37 4.1534585187917715e-09
R37 m37 n38 0.00010450781339548083
C37 n37 0 2.926501447922784e-10
L38 n38 m38 4.1534585187917715e-09
R38 m38 n39 0.00010450781339548083
C38 n38 0 2.926501447922784e-10
L39 n39 m39 4.1534585187917715e-09
R39 m39 n40 0.00010450781339548083
C39 n39 0 2.926501447922784e-10
L40 n40 m40 4.1534585187917715e-09
R40 m40 n41 0.00010450781339548083
C40 n40 0 2.926501447922784e-10
L41 n41 m41 4.1534585187917715e-09
R41 m41 n42 0.00010450781339548083
C41 n41 0 2.926501447922784e-10
L42 n42 m42 4.1534585187917715e-09
R42 m42 n43 0.00010450781339548083
C42 n42 0 2.926501447922784e-10
L43 n43 m43 4.1534585187917715e-09
R43 m43 n44 0.00010450781339548083
C43 n43 0 2.926501447922784e-10
L44 n44 m44 4.1534585187917715e-09
R44 m44 n45 0.00010450781339548083
C44 n44 0 2.926501447922784e-10
L45 n45 m45 4.1534585187917715e-09
R45 m45 n46 0.00010450781339548083
C45 n45 0 2.926501447922784e-10
L46 n46 m46 4.1534585187917715e-09
R46 m46 n47 0.00010450781339548083
C46 n46 0 2.926501447922784e-10
L47 n47 m47 4.1534585187917715e-09
R47 m47 n48 0.00010450781339548083
C47 n47 0 2.926501447922784e-10
L48 n48 m48 4.1534585187917715e-09
R48 m48 n49 0.00010450781339548083
C48 n48 0 2.926501447922784e-10
L49 n49 m49 4.1534585187917715e-09
R49 m49 n50 0.00010450781339548083
C49 n49 0 2.926501447922784e-10
L50 n50 m50 4.1534585187917715e-09
R50 m50 n51 0.00010450781339548083
C50 n50 0 2.926501447922784e-10
L51 n51 m51 4.1534585187917715e-09
R51 m51 n52 0.00010450781339548083
C51 n51 0 2.926501447922784e-10
L52 n52 m52 4.1534585187917715e-09
R52 m52 n53 0.00010450781339548083
C52 n52 0 2.926501447922784e-10
L53 n53 m53 4.1534585187917715e-09
R53 m53 n54 0.00010450781339548083
C53 n53 0 2.926501447922784e-10
L54 n54 m54 4.1534585187917715e-09
R54 m54 n55 0.00010450781339548083
C54 n54 0 2.926501447922784e-10
L55 n55 m55 4.1534585187917715e-09
R55 m55 n56 0.00010450781339548083
C55 n55 0 2.926501447922784e-10
L56 n56 m56 4.1534585187917715e-09
R56 m56 n57 0.00010450781339548083
C56 n56 0 2.926501447922784e-10
L57 n57 m57 4.1534585187917715e-09
R57 m57 n58 0.00010450781339548083
C57 n57 0 2.926501447922784e-10
L58 n58 m58 4.1534585187917715e-09
R58 m58 n59 0.00010450781339548083
C58 n58 0 2.926501447922784e-10
L59 n59 m59 4.1534585187917715e-09
R59 m59 n60 0.00010450781339548083
C59 n59 0 2.926501447922784e-10
L60 n60 m60 4.1534585187917715e-09
R60 m60 n61 0.00010450781339548083
C60 n60 0 2.926501447922784e-10
L61 n61 m61 4.1534585187917715e-09
R61 m61 n62 0.00010450781339548083
C61 n61 0 2.926501447922784e-10
L62 n62 m62 4.1534585187917715e-09
R62 m62 n63 0.00010450781339548083
C62 n62 0 2.926501447922784e-10
L63 n63 m63 4.1534585187917715e-09
R63 m63 n64 0.00010450781339548083
C63 n63 0 2.926501447922784e-10
L64 n64 m64 4.1534585187917715e-09
R64 m64 n65 0.00010450781339548083
C64 n64 0 2.926501447922784e-10
L65 n65 m65 4.1534585187917715e-09
R65 m65 n66 0.00010450781339548083
C65 n65 0 2.926501447922784e-10
L66 n66 m66 4.1534585187917715e-09
R66 m66 n67 0.00010450781339548083
C66 n66 0 2.926501447922784e-10
L67 n67 m67 4.1534585187917715e-09
R67 m67 n68 0.00010450781339548083
C67 n67 0 2.926501447922784e-10
L68 n68 m68 4.1534585187917715e-09
R68 m68 n69 0.00010450781339548083
C68 n68 0 2.926501447922784e-10
L69 n69 m69 4.1534585187917715e-09
R69 m69 n70 0.00010450781339548083
C69 n69 0 2.926501447922784e-10
L70 n70 m70 4.1534585187917715e-09
R70 m70 n71 0.00010450781339548083
C70 n70 0 2.926501447922784e-10
L71 n71 m71 4.1534585187917715e-09
R71 m71 n72 0.00010450781339548083
C71 n71 0 2.926501447922784e-10
L72 n72 m72 4.1534585187917715e-09
R72 m72 n73 0.00010450781339548083
C72 n72 0 2.926501447922784e-10
L73 n73 m73 4.1534585187917715e-09
R73 m73 n74 0.00010450781339548083
C73 n73 0 2.926501447922784e-10
L74 n74 m74 4.1534585187917715e-09
R74 m74 n75 0.00010450781339548083
C74 n74 0 2.926501447922784e-10
L75 n75 m75 4.1534585187917715e-09
R75 m75 n76 0.00010450781339548083
C75 n75 0 2.926501447922784e-10
L76 n76 m76 4.1534585187917715e-09
R76 m76 n77 0.00010450781339548083
C76 n76 0 2.926501447922784e-10
L77 n77 m77 4.1534585187917715e-09
R77 m77 n78 0.00010450781339548083
C77 n77 0 2.926501447922784e-10
L78 n78 m78 4.1534585187917715e-09
R78 m78 n79 0.00010450781339548083
C78 n78 0 2.926501447922784e-10
L79 n79 m79 4.1534585187917715e-09
R79 m79 n80 0.00010450781339548083
C79 n79 0 2.926501447922784e-10
L80 n80 m80 4.1534585187917715e-09
R80 m80 n81 0.00010450781339548083
C80 n80 0 2.926501447922784e-10
L81 n81 m81 4.1534585187917715e-09
R81 m81 n82 0.00010450781339548083
C81 n81 0 2.926501447922784e-10
L82 n82 m82 4.1534585187917715e-09
R82 m82 n83 0.00010450781339548083
C82 n82 0 2.926501447922784e-10
L83 n83 m83 4.1534585187917715e-09
R83 m83 n84 0.00010450781339548083
C83 n83 0 2.926501447922784e-10
L84 n84 m84 4.1534585187917715e-09
R84 m84 n85 0.00010450781339548083
C84 n84 0 2.926501447922784e-10
L85 n85 m85 4.1534585187917715e-09
R85 m85 n86 0.00010450781339548083
C85 n85 0 2.926501447922784e-10
L86 n86 m86 4.1534585187917715e-09
R86 m86 n87 0.00010450781339548083
C86 n86 0 2.926501447922784e-10
L87 n87 m87 4.1534585187917715e-09
R87 m87 n88 0.00010450781339548083
C87 n87 0 2.926501447922784e-10
L88 n88 m88 4.1534585187917715e-09
R88 m88 n89 0.00010450781339548083
C88 n88 0 2.926501447922784e-10
L89 n89 m89 4.1534585187917715e-09
R89 m89 n90 0.00010450781339548083
C89 n89 0 2.926501447922784e-10
L90 n90 m90 4.1534585187917715e-09
R90 m90 n91 0.00010450781339548083
C90 n90 0 2.926501447922784e-10
L91 n91 m91 4.1534585187917715e-09
R91 m91 n92 0.00010450781339548083
C91 n91 0 2.926501447922784e-10
L92 n92 m92 4.1534585187917715e-09
R92 m92 n93 0.00010450781339548083
C92 n92 0 2.926501447922784e-10
L93 n93 m93 4.1534585187917715e-09
R93 m93 n94 0.00010450781339548083
C93 n93 0 2.926501447922784e-10
L94 n94 m94 4.1534585187917715e-09
R94 m94 n95 0.00010450781339548083
C94 n94 0 2.926501447922784e-10
L95 n95 m95 4.1534585187917715e-09
R95 m95 n0 0.00010450781339548083
C95 n95 0 2.926501447922784e-10
IA1 0 n0 DC 0 AC 0.29727962190764806 0
IA2 0 n6 DC 0 AC 0.29727962190764806 -90
IB1 0 n48 DC 0 AC 0.29727962190764806 -0
IB2 0 n54 DC 0 AC 0.29727962190764806 -90
VDC bias 0 DC 2500
RB bias n0 1e+07
.ac lin 1 37684997.052590802 37684997.052590802
.end
