light rings
Lp n0 0 7.547719174154282e-22
Ip 0 n0 PWL(0 0 1e-09 13015.065493835544 2e-09 13015.065493835544)
Le n1 0 1.2717750951362622e-21
Ie 0 n1 PWL(0 0 1e-09 -7724.169136223822 2e-09 -7724.169136223822)
Kpe Lp Le 0.8227940968808045
.tran 10p 2n
.end
