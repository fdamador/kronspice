light rings
La n0 0 7.547719174154282e-22
Ia 0 n0 PWL(0 0 1e-09 8676.710329223695 2e-09 8676.710329223695)
Lb n1 0 7.547719174154282e-22
Ib 0 n1 PWL(0 0 1e-09 8676.710329223695 2e-09 8676.710329223695)
Lc n2 0 7.547719174154282e-22
Ic 0 n2 PWL(0 0 1e-09 4338.355164611848 2e-09 4338.355164611848)
Kab La Lb 0.3844900105848798
Kac La Lc 0.11039486357681029
Kbc Lb Lc 0.3844900105848798
.tran 10p 2n
.end
