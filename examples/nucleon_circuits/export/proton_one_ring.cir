light rings
Lp n0 0 2.702517625485976e-22
Ip 0 n0 PWL(0 0 1e-09 36349.09110464414 2e-09 36349.09110464414)
.tran 10p 2n
.end
