bearden_meg knife V=20 f=10000 RL=100 mismatch=1 Cres=0 gap=0.15 leak=0
* magnetic domain: node voltage = MMF [A], branch current = flux rate [V]
.domain magnetic a1 al jl y1 n y2 y3 jr br b1
VMA a1 0 PWL(0 0 0.0005 4500)
CMA a1 al 2.638937829e-08
CYA al jl Q=pwl(-3750 -0.0001723150432 -75 -0.00016 -37.5 -0.00015 -15 -0.00013 -7.5 -0.0001 -3.75 -6e-05 0 0 3.75 6e-05 7.5 0.0001 15 0.00013 37.5 0.00015 75 0.00016 3750 0.0001723150432)
VMB b1 0 PWL(0 0 0.0005 4500)
CMB b1 br 2.638937829e-08
CYB br jr Q=pwl(-3750 -0.0001723150432 -75 -0.00016 -37.5 -0.00015 -15 -0.00013 -7.5 -0.0001 -3.75 -6e-05 0 0 3.75 6e-05 7.5 0.0001 15 0.00013 37.5 0.00015 75 0.00016 3750 0.0001723150432)
YDR1 d1 dm jl y1 0.04
CB1 y1 n Q=pwl(-3750 -0.0001723150432 -75 -0.00016 -37.5 -0.00015 -15 -0.00013 -7.5 -0.0001 -3.75 -6e-05 0 0 3.75 6e-05 7.5 0.0001 15 0.00013 37.5 0.00015 75 0.00016 3750 0.0001723150432)
YOUT o1 0 n y2 0.005
CB2 y2 y3 Q=pwl(-3750 -0.0001723150432 -75 -0.00016 -37.5 -0.00015 -15 -0.00013 -7.5 -0.0001 -3.75 -6e-05 0 0 3.75 6e-05 7.5 0.0001 15 0.00013 37.5 0.00015 75 0.00016 3750 0.0001723150432)
YDR2 dm 0 y3 jr 0.04
RDM dm 0 1000000
CRL jl 0 Q=pwl(-5000 -0.0001723150432 -100 -0.00016 -50 -0.00015 -20 -0.00013 -10 -0.0001 -5 -6e-05 0 0 5 6e-05 10 0.0001 20 0.00013 50 0.00015 100 0.00016 5000 0.0001723150432)
CRR jr 0 Q=pwl(-5000 -0.0001723150432 -100 -0.00016 -50 -0.00015 -20 -0.00013 -10 -0.0001 -5 -6e-05 0 0 5 6e-05 10 0.0001 20 0.00013 50 0.00015 100 0.00016 5000 0.0001723150432)
RKAL al 0 1e+12
RKJL jl 0 1e+12
RKY1 y1 0 1e+12
RKN n 0 1e+12
RKY2 y2 0 1e+12
RKY3 y3 0 1e+12
RKJR jr 0 1e+12
RKBR br 0 1e+12
VD ds 0 SIN(0 20 10000 0)
RS ds d1 1
RL o1 0 100
.tran 1e-07 0.012
.end
