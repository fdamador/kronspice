bearden_meg knife V=2 f=10000 RL=100 mismatch=1 Cres=0 gap=0.15 leak=0 (ngspice twin)
* columns: v(ds) i(vd) v(a1) i(vma) v(b1) i(vmb) v(o1) v(d1) v(dm) v(jl) v(n) v(jr)
VMA a1 0 PWL(0 0 0.0005 4500)
CMA a1 al 2.638937829e-08
BCYA al jl I=ddt(pwl(v(al,jl), -3750, -0.0001723150432, -75, -0.00016, -37.5, -0.00015, -15, -0.00013, -7.5, -0.0001, -3.75, -6e-05, 0, 0, 3.75, 6e-05, 7.5, 0.0001, 15, 0.00013, 37.5, 0.00015, 75, 0.00016, 3750, 0.0001723150432))
VMB b1 0 PWL(0 0 0.0005 4500)
CMB b1 br 2.638937829e-08
BCYB br jr I=ddt(pwl(v(br,jr), -3750, -0.0001723150432, -75, -0.00016, -37.5, -0.00015, -15, -0.00013, -7.5, -0.0001, -3.75, -6e-05, 0, 0, 3.75, 6e-05, 7.5, 0.0001, 15, 0.00013, 37.5, 0.00015, 75, 0.00016, 3750, 0.0001723150432))
GYDR1_1 d1 dm jl y1 0.04
GYDR1_2 jl y1 d1 dm -0.04
BCB1 y1 n I=ddt(pwl(v(y1,n), -3750, -0.0001723150432, -75, -0.00016, -37.5, -0.00015, -15, -0.00013, -7.5, -0.0001, -3.75, -6e-05, 0, 0, 3.75, 6e-05, 7.5, 0.0001, 15, 0.00013, 37.5, 0.00015, 75, 0.00016, 3750, 0.0001723150432))
GYOUT_1 o1 0 n y2 0.005
GYOUT_2 n y2 o1 0 -0.005
BCB2 y2 y3 I=ddt(pwl(v(y2,y3), -3750, -0.0001723150432, -75, -0.00016, -37.5, -0.00015, -15, -0.00013, -7.5, -0.0001, -3.75, -6e-05, 0, 0, 3.75, 6e-05, 7.5, 0.0001, 15, 0.00013, 37.5, 0.00015, 75, 0.00016, 3750, 0.0001723150432))
GYDR2_1 dm 0 y3 jr 0.04
GYDR2_2 y3 jr dm 0 -0.04
RDM dm 0 1000000
BCRL jl 0 I=ddt(pwl(v(jl,0), -5000, -0.0001723150432, -100, -0.00016, -50, -0.00015, -20, -0.00013, -10, -0.0001, -5, -6e-05, 0, 0, 5, 6e-05, 10, 0.0001, 20, 0.00013, 50, 0.00015, 100, 0.00016, 5000, 0.0001723150432))
BCRR jr 0 I=ddt(pwl(v(jr,0), -5000, -0.0001723150432, -100, -0.00016, -50, -0.00015, -20, -0.00013, -10, -0.0001, -5, -6e-05, 0, 0, 5, 6e-05, 10, 0.0001, 20, 0.00013, 50, 0.00015, 100, 0.00016, 5000, 0.0001723150432))
RKAL al 0 1e+12
RKJL jl 0 1e+12
RKY1 y1 0 1e+12
RKN n 0 1e+12
RKY2 y2 0 1e+12
RKY3 y3 0 1e+12
RKJR jr 0 1e+12
RKBR br 0 1e+12
VD ds 0 SIN(0 2 10000 0)
RS ds d1 1
RL o1 0 100
.options reltol=1e-4 abstol=1e-12 vntol=1e-9 chgtol=1e-16 method=gear
.tran 1e-07 0.012 0 1e-07
.control
run
linearize
wrdata knife_baseline.dat v(ds) i(vd) v(a1) i(vma) v(b1) i(vmb) v(o1) v(d1) v(dm) v(jl) v(n) v(jr)
quit
.endc
.end
