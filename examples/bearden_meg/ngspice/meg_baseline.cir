bearden_meg meg V=5 f=10000 RL=100 (ngspice twin)
* columns: v(dl) i(vdl) v(dr) i(vdr) v(m1) i(vm) v(ol) v(or) v(l2) v(r2)
VM m1 0 PWL(0 0 0.0005 4500)
CM m1 t 2.638937829e-08
GYCL_1 cl 0 t l1 0.02
GYCL_2 t l1 cl 0 -0.02
GYOL_1 ol 0 l1 l2 0.005
GYOL_2 l1 l2 ol 0 -0.005
BCL l2 0 I=ddt(pwl(v(l2,0), -5000, -0.0001723150432, -100, -0.00016, -50, -0.00015, -20, -0.00013, -10, -0.0001, -5, -6e-05, 0, 0, 5, 6e-05, 10, 0.0001, 20, 0.00013, 50, 0.00015, 100, 0.00016, 5000, 0.0001723150432))
GYCR_1 cr 0 t r1 0.02
GYCR_2 t r1 cr 0 -0.02
GYOR_1 or 0 r1 r2 0.005
GYOR_2 r1 r2 or 0 -0.005
BCR r2 0 I=ddt(pwl(v(r2,0), -5000, -0.0001723150432, -100, -0.00016, -50, -0.00015, -20, -0.00013, -10, -0.0001, -5, -6e-05, 0, 0, 5, 6e-05, 10, 0.0001, 20, 0.00013, 50, 0.00015, 100, 0.00016, 5000, 0.0001723150432))
RKT t 0 1e+12
RKL1 l1 0 1e+12
RKL2 l2 0 1e+12
RKR1 r1 0 1e+12
RKR2 r2 0 1e+12
VDL dl 0 PULSE(0 5 0.001 1u 1u 4.5e-05 0.0001)
VDR dr 0 PULSE(0 5 0.00105 1u 1u 4.5e-05 0.0001)
RSL dl cl 1
RSR dr cr 1
RLL ol 0 100
RLR or 0 100
.options reltol=1e-4 abstol=1e-12 vntol=1e-9 chgtol=1e-16 method=gear
.tran 1e-07 0.003 0 1e-07
.control
run
linearize
wrdata meg_baseline.dat v(dl) i(vdl) v(dr) i(vdr) v(m1) i(vm) v(ol) v(or) v(l2) v(r2)
quit
.endc
.end
