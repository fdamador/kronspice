water-cell bridge rectifier
VAC s 0 SIN(0 100 60)
RS s ac1 0.5
BDA0 ac1 p I=pwl(V(ac1,p), -2800, -1266.7666666666664, -140, -0.1, -2, -0.0014285714285714286, 0, 0, 2, 0, 140, 1380, 2800, 27980)
CDA0 ac1 p 4.378444522813186e-06
BDB0 0 p I=pwl(V(0,p), -2800, -1266.7666666666664, -140, -0.1, -2, -0.0014285714285714286, 0, 0, 2, 0, 140, 1380, 2800, 27980)
CDB0 0 p 4.378444522813186e-06
BDC0 n ac1 I=pwl(V(n,ac1), -2800, -1266.7666666666664, -140, -0.1, -2, -0.0014285714285714286, 0, 0, 2, 0, 140, 1380, 2800, 27980)
CDC0 n ac1 4.378444522813186e-06
BDD0 n 0 I=pwl(V(n), -2800, -1266.7666666666664, -140, -0.1, -2, -0.0014285714285714286, 0, 0, 2, 0, 140, 1380, 2800, 27980)
CDD0 n 0 4.378444522813186e-06
RREF n 0 1e+09
CL p n 0.0022
RL p n 50
.tran 41.7u 0.5
.end
