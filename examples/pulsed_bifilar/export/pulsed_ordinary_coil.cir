ordinary cylindrical solenoid coil, pulse driven through a primary
VP s 0 DC 0 AC 1 0
RS s p 50
LP p 0 5.974707646431556e-06
RB n0 0 1e+09
KP0 LP L0 0.42680557501388827
KP1 LP L1 0.2721132403129076
KP2 LP L2 0.1799598791708485
KP3 LP L3 0.12346232882263905
KP4 LP L4 0.08723602410316152
KP5 LP L5 0.06321164772268692
KP6 LP L6 0.04684013903686644
KP7 LP L7 0.03541718394342051
KP8 LP L8 0.0272752641483815
KP9 LP L9 0.02135731333975111
KP10 LP L10 0.016977559081940753
KP11 LP L11 0.013681818455761623
KP12 LP L12 0.01116348989496939
KP13 LP L13 0.009211860398564592
KP14 LP L14 0.007679656285802311
KP15 LP L15 0.006462298322978835
KP16 LP L16 0.005484409742518989
KP17 LP L17 0.004690896913556464
KP18 LP L18 0.004040960387778687
KP19 LP L19 0.0035040134473017914
L0 n0 m0 7.094623644916161e-05
R0 m0 n1 1.0301358482175147
L1 n1 m1 7.094623644916158e-05
R1 m1 n2 1.0301358482175147
L2 n2 m2 7.094623644916157e-05
R2 m2 n3 1.0301358482175147
L3 n3 m3 7.094623644916158e-05
R3 m3 n4 1.0301358482175147
L4 n4 m4 7.094623644916157e-05
R4 m4 n5 1.0301358482175147
L5 n5 m5 7.094623644916156e-05
R5 m5 n6 1.0301358482175147
L6 n6 m6 7.094623644916157e-05
R6 m6 n7 1.0301358482175147
L7 n7 m7 7.094623644916156e-05
R7 m7 n8 1.0301358482175147
L8 n8 m8 7.094623644916154e-05
R8 m8 n9 1.0301358482175147
L9 n9 m9 7.09462364491616e-05
R9 m9 n10 1.0301358482175147
L10 n10 m10 7.094623644916158e-05
R10 m10 n11 1.0301358482175147
L11 n11 m11 7.094623644916161e-05
R11 m11 n12 1.0301358482175147
L12 n12 m12 7.09462364491616e-05
R12 m12 n13 1.0301358482175147
L13 n13 m13 7.09462364491616e-05
R13 m13 n14 1.0301358482175147
L14 n14 m14 7.094623644916158e-05
R14 m14 n15 1.0301358482175147
L15 n15 m15 7.094623644916158e-05
R15 m15 n16 1.0301358482175147
L16 n16 m16 7.09462364491616e-05
R16 m16 n17 1.0301358482175147
L17 n17 m17 7.094623644916157e-05
R17 m17 n18 1.0301358482175147
L18 n18 m18 7.094623644916164e-05
R18 m18 n19 1.0301358482175147
L19 n19 m19 7.094623644916164e-05
R19 m19 n20 1.0301358482175147
K0 L0 L1 0.5359976238668082
K1 L0 L2 0.2895665341372655
K2 L0 L3 0.18059350877887398
K3 L0 L4 0.11927752517724792
K4 L0 L5 0.08188071854218987
K5 L0 L6 0.05797963179804206
K6 L0 L7 0.04216704701948546
K7 L0 L8 0.03139970200492183
K8 L0 L9 0.023879111151520478
K9 L0 L10 0.01850463920657092
K10 L0 L11 0.01458327509847409
K11 L0 L12 0.011667625362772554
K12 L0 L13 0.00946222097022547
K13 L0 L14 0.007767789934202172
K14 L0 L15 0.0064472973980332525
K15 L0 L16 0.00540478982282959
K16 L0 L17 0.004571943298570559
K17 L0 L18 0.0038993448456989288
K18 L0 L19 0.003350738604128597
K19 L1 L2 0.5359976238668084
K20 L1 L3 0.28956653413726574
K21 L1 L4 0.180593508778874
K22 L1 L5 0.11927752517724816
K23 L1 L6 0.08188071854218994
K24 L1 L7 0.05797963179804217
K25 L1 L8 0.04216704701948546
K26 L1 L9 0.03139970200492179
K27 L1 L10 0.02387911115152049
K28 L1 L11 0.01850463920657098
K29 L1 L12 0.014583275098474057
K30 L1 L13 0.01166762536277254
K31 L1 L14 0.009462220970225494
K32 L1 L15 0.007767789934202173
K33 L1 L16 0.0064472973980332065
K34 L1 L17 0.005404789822829592
K35 L1 L18 0.004571943298570581
K36 L1 L19 0.003899344845698875
K37 L2 L3 0.5359976238668082
K38 L2 L4 0.2895665341372658
K39 L2 L5 0.18059350877887415
K40 L2 L6 0.11927752517724804
K41 L2 L7 0.08188071854219008
K42 L2 L8 0.05797963179804226
K43 L2 L9 0.04216704701948552
K44 L2 L10 0.031399702004921794
K45 L2 L11 0.023879111151520454
K46 L2 L12 0.018504639206570906
K47 L2 L13 0.01458327509847404
K48 L2 L14 0.01166762536277256
K49 L2 L15 0.009462220970225473
K50 L2 L16 0.007767789934202152
K51 L2 L17 0.006447297398033229
K52 L2 L18 0.005404789822829548
K53 L2 L19 0.004571943298570608
K54 L3 L4 0.5359976238668083
K55 L3 L5 0.28956653413726574
K56 L3 L6 0.18059350877887406
K57 L3 L7 0.11927752517724807
K58 L3 L8 0.08188071854219009
K59 L3 L9 0.057979631798042185
K60 L3 L10 0.04216704701948548
K61 L3 L11 0.03139970200492177
K62 L3 L12 0.02387911115152046
K63 L3 L13 0.018504639206570906
K64 L3 L14 0.014583275098474078
K65 L3 L15 0.011667625362772544
K66 L3 L16 0.009462220970225492
K67 L3 L17 0.007767789934202133
K68 L3 L18 0.006447297398033206
K69 L3 L19 0.0054047898228295425
K70 L4 L5 0.5359976238668084
K71 L4 L6 0.2895665341372657
K72 L4 L7 0.18059350877887412
K73 L4 L8 0.11927752517724818
K74 L4 L9 0.08188071854218994
K75 L4 L10 0.05797963179804219
K76 L4 L11 0.0421670470194855
K77 L4 L12 0.03139970200492182
K78 L4 L13 0.02387911115152053
K79 L4 L14 0.01850463920657092
K80 L4 L15 0.014583275098474036
K81 L4 L16 0.011667625362772587
K82 L4 L17 0.009462220970225475
K83 L4 L18 0.0077677899342021165
K84 L4 L19 0.00644729739803314
K85 L5 L6 0.5359976238668085
K86 L5 L7 0.28956653413726585
K87 L5 L8 0.18059350877887423
K88 L5 L9 0.11927752517724804
K89 L5 L10 0.08188071854218992
K90 L5 L11 0.057979631798042094
K91 L5 L12 0.042167047019485475
K92 L5 L13 0.03139970200492183
K93 L5 L14 0.02387911115152055
K94 L5 L15 0.01850463920657095
K95 L5 L16 0.014583275098473937
K96 L5 L17 0.011667625362772703
K97 L5 L18 0.009462220970225508
K98 L5 L19 0.007767789934202118
K99 L6 L7 0.5359976238668086
K100 L6 L8 0.28956653413726574
K101 L6 L9 0.18059350877887423
K102 L6 L10 0.11927752517724807
K103 L6 L11 0.08188071854218992
K104 L6 L12 0.05797963179804214
K105 L6 L13 0.04216704701948551
K106 L6 L14 0.03139970200492185
K107 L6 L15 0.023879111151520523
K108 L6 L16 0.01850463920657093
K109 L6 L17 0.01458327509847395
K110 L6 L18 0.011667625362772658
K111 L6 L19 0.009462220970225506
K112 L7 L8 0.5359976238668085
K113 L7 L9 0.28956653413726574
K114 L7 L10 0.18059350877887417
K115 L7 L11 0.11927752517724807
K116 L7 L12 0.08188071854218994
K117 L7 L13 0.05797963179804212
K118 L7 L14 0.04216704701948552
K119 L7 L15 0.03139970200492184
K120 L7 L16 0.023879111151520575
K121 L7 L17 0.01850463920657092
K122 L7 L18 0.014583275098473989
K123 L7 L19 0.011667625362772719
K124 L8 L9 0.5359976238668086
K125 L8 L10 0.28956653413726585
K126 L8 L11 0.18059350877887417
K127 L8 L12 0.11927752517724809
K128 L8 L13 0.08188071854218994
K129 L8 L14 0.05797963179804216
K130 L8 L15 0.04216704701948551
K131 L8 L16 0.03139970200492186
K132 L8 L17 0.023879111151520603
K133 L8 L18 0.018504639206570903
K134 L8 L19 0.01458327509847395
K135 L9 L10 0.5359976238668082
K136 L9 L11 0.28956653413726513
K137 L9 L12 0.1805935087788738
K138 L9 L13 0.11927752517724848
K139 L9 L14 0.08188071854219009
K140 L9 L15 0.05797963179804232
K141 L9 L16 0.042167047019485475
K142 L9 L17 0.031399702004921905
K143 L9 L18 0.02387911115152055
K144 L9 L19 0.018504639206570903
K145 L10 L11 0.5359976238668079
K146 L10 L12 0.28956653413726524
K147 L10 L13 0.18059350877887384
K148 L10 L14 0.11927752517724842
K149 L10 L15 0.08188071854219013
K150 L10 L16 0.05797963179804235
K151 L10 L17 0.042167047019485544
K152 L10 L18 0.031399702004921905
K153 L10 L19 0.023879111151520607
K154 L11 L12 0.5359976238668082
K155 L11 L13 0.28956653413726524
K156 L11 L14 0.1805935087788738
K157 L11 L15 0.11927752517724852
K158 L11 L16 0.0818807185421901
K159 L11 L17 0.0579796317980423
K160 L11 L18 0.04216704701948552
K161 L11 L19 0.03139970200492188
K162 L12 L13 0.535997623866808
K163 L12 L14 0.2895665341372651
K164 L12 L15 0.1805935087788738
K165 L12 L16 0.11927752517724843
K166 L12 L17 0.08188071854219012
K167 L12 L18 0.05797963179804224
K168 L12 L19 0.042167047019485523
K169 L13 L14 0.535997623866808
K170 L13 L15 0.2895665341372652
K171 L13 L16 0.18059350877887384
K172 L13 L17 0.11927752517724845
K173 L13 L18 0.0818807185421899
K174 L13 L19 0.05797963179804222
K175 L14 L15 0.5359976238668082
K176 L14 L16 0.2895665341372652
K177 L14 L17 0.18059350877887387
K178 L14 L18 0.11927752517724814
K179 L14 L19 0.08188071854218995
K180 L15 L16 0.5359976238668082
K181 L15 L17 0.2895665341372653
K182 L15 L18 0.18059350877887384
K183 L15 L19 0.11927752517724804
K184 L16 L17 0.5359976238668083
K185 L16 L18 0.28956653413726535
K186 L16 L19 0.18059350877887384
K187 L17 L18 0.5359976238668087
K188 L17 L19 0.2895665341372655
K189 L18 L19 0.5359976238668079
CG0 n0 0 5.618251510338399e-13
CG1 n1 0 1.1236503020676798e-12
CG2 n2 0 1.1236503020676798e-12
CG3 n3 0 1.1236503020676798e-12
CG4 n4 0 1.1236503020676798e-12
CG5 n5 0 1.1236503020676798e-12
CG6 n6 0 1.1236503020676798e-12
CG7 n7 0 1.1236503020676798e-12
CG8 n8 0 1.1236503020676798e-12
CG9 n9 0 1.1236503020676798e-12
CG10 n10 0 1.1236503020676798e-12
CG11 n11 0 1.1236503020676798e-12
CG12 n12 0 1.1236503020676798e-12
CG13 n13 0 1.1236503020676798e-12
CG14 n14 0 1.1236503020676798e-12
CG15 n15 0 1.1236503020676798e-12
CG16 n16 0 1.1236503020676798e-12
CG17 n17 0 1.1236503020676798e-12
CG18 n18 0 1.1236503020676798e-12
CG19 n19 0 1.1236503020676798e-12
CG20 n20 0 5.618251510338399e-13
CA0 n0 n1 1.5118658599780558e-11
CA1 n1 n2 1.5118658599780558e-11
CA2 n1 n2 1.5118658599780558e-11
CA3 n2 n3 1.5118658599780558e-11
CA4 n2 n3 1.5118658599780558e-11
CA5 n3 n4 1.5118658599780558e-11
CA6 n3 n4 1.5118658599780558e-11
CA7 n4 n5 1.5118658599780558e-11
CA8 n4 n5 1.5118658599780558e-11
CA9 n5 n6 1.5118658599780558e-11
CA10 n5 n6 1.5118658599780558e-11
CA11 n6 n7 1.5118658599780558e-11
CA12 n6 n7 1.5118658599780558e-11
CA13 n7 n8 1.5118658599780558e-11
CA14 n7 n8 1.5118658599780558e-11
CA15 n8 n9 1.5118658599780558e-11
CA16 n8 n9 1.5118658599780558e-11
CA17 n9 n10 1.5118658599780558e-11
CA18 n9 n10 1.5118658599780558e-11
CA19 n10 n11 1.5118658599780558e-11
CA20 n10 n11 1.5118658599780558e-11
CA21 n11 n12 1.5118658599780558e-11
CA22 n11 n12 1.5118658599780558e-11
CA23 n12 n13 1.5118658599780558e-11
CA24 n12 n13 1.5118658599780558e-11
CA25 n13 n14 1.5118658599780558e-11
CA26 n13 n14 1.5118658599780558e-11
CA27 n14 n15 1.5118658599780558e-11
CA28 n14 n15 1.5118658599780558e-11
CA29 n15 n16 1.5118658599780558e-11
CA30 n15 n16 1.5118658599780558e-11
CA31 n16 n17 1.5118658599780558e-11
CA32 n16 n17 1.5118658599780558e-11
CA33 n17 n18 1.5118658599780558e-11
CA34 n17 n18 1.5118658599780558e-11
CA35 n18 n19 1.5118658599780558e-11
CA36 n18 n19 1.5118658599780558e-11
CA37 n19 n20 1.5118658599780558e-11
.ac dec 50 100k 10meg
.end
