coupled microstrip pair
V1 src 0 DC 0 AC 1 0
RS src a_in 47.801769985781924
RA a_out 0 47.801769985781924
RVN v_in 0 47.801769985781924
RVF v_out 0 47.801769985781924
LX0_a0 a_in x0_m0 7.240277495153368e-10
LX1_a0 v_in x1_m0 7.240277495153364e-10
KX01_a0 LX0_a0 LX1_a0 0.1276995674610439
LX0_b0 x0_m0 x0_n1 7.240277495153368e-10
LX1_b0 x1_m0 x1_n1 7.240277495153364e-10
KX01_b0 LX0_b0 LX1_b0 0.1276995674610439
CX0_g0 x0_m0 0 5.942475582044419e-13
CX01_0 x0_m0 x1_m0 3.947220550682456e-14
CX1_g0 x1_m0 0 5.942475582044421e-13
LX0_a1 x0_n1 x0_m1 7.240277495153368e-10
LX1_a1 x1_n1 x1_m1 7.240277495153364e-10
KX01_a1 LX0_a1 LX1_a1 0.1276995674610439
LX0_b1 x0_m1 x0_n2 7.240277495153368e-10
LX1_b1 x1_m1 x1_n2 7.240277495153364e-10
KX01_b1 LX0_b1 LX1_b1 0.1276995674610439
CX0_g1 x0_m1 0 5.942475582044419e-13
CX01_1 x0_m1 x1_m1 3.947220550682456e-14
CX1_g1 x1_m1 0 5.942475582044421e-13
LX0_a2 x0_n2 x0_m2 7.240277495153368e-10
LX1_a2 x1_n2 x1_m2 7.240277495153364e-10
KX01_a2 LX0_a2 LX1_a2 0.1276995674610439
LX0_b2 x0_m2 x0_n3 7.240277495153368e-10
LX1_b2 x1_m2 x1_n3 7.240277495153364e-10
KX01_b2 LX0_b2 LX1_b2 0.1276995674610439
CX0_g2 x0_m2 0 5.942475582044419e-13
CX01_2 x0_m2 x1_m2 3.947220550682456e-14
CX1_g2 x1_m2 0 5.942475582044421e-13
LX0_a3 x0_n3 x0_m3 7.240277495153368e-10
LX1_a3 x1_n3 x1_m3 7.240277495153364e-10
KX01_a3 LX0_a3 LX1_a3 0.1276995674610439
LX0_b3 x0_m3 x0_n4 7.240277495153368e-10
LX1_b3 x1_m3 x1_n4 7.240277495153364e-10
KX01_b3 LX0_b3 LX1_b3 0.1276995674610439
CX0_g3 x0_m3 0 5.942475582044419e-13
CX01_3 x0_m3 x1_m3 3.947220550682456e-14
CX1_g3 x1_m3 0 5.942475582044421e-13
LX0_a4 x0_n4 x0_m4 7.240277495153368e-10
LX1_a4 x1_n4 x1_m4 7.240277495153364e-10
KX01_a4 LX0_a4 LX1_a4 0.1276995674610439
LX0_b4 x0_m4 x0_n5 7.240277495153368e-10
LX1_b4 x1_m4 x1_n5 7.240277495153364e-10
KX01_b4 LX0_b4 LX1_b4 0.1276995674610439
CX0_g4 x0_m4 0 5.942475582044419e-13
CX01_4 x0_m4 x1_m4 3.947220550682456e-14
CX1_g4 x1_m4 0 5.942475582044421e-13
LX0_a5 x0_n5 x0_m5 7.240277495153368e-10
LX1_a5 x1_n5 x1_m5 7.240277495153364e-10
KX01_a5 LX0_a5 LX1_a5 0.1276995674610439
LX0_b5 x0_m5 x0_n6 7.240277495153368e-10
LX1_b5 x1_m5 x1_n6 7.240277495153364e-10
KX01_b5 LX0_b5 LX1_b5 0.1276995674610439
CX0_g5 x0_m5 0 5.942475582044419e-13
CX01_5 x0_m5 x1_m5 3.947220550682456e-14
CX1_g5 x1_m5 0 5.942475582044421e-13
LX0_a6 x0_n6 x0_m6 7.240277495153368e-10
LX1_a6 x1_n6 x1_m6 7.240277495153364e-10
KX01_a6 LX0_a6 LX1_a6 0.1276995674610439
LX0_b6 x0_m6 x0_n7 7.240277495153368e-10
LX1_b6 x1_m6 x1_n7 7.240277495153364e-10
KX01_b6 LX0_b6 LX1_b6 0.1276995674610439
CX0_g6 x0_m6 0 5.942475582044419e-13
CX01_6 x0_m6 x1_m6 3.947220550682456e-14
CX1_g6 x1_m6 0 5.942475582044421e-13
LX0_a7 x0_n7 x0_m7 7.240277495153368e-10
LX1_a7 x1_n7 x1_m7 7.240277495153364e-10
KX01_a7 LX0_a7 LX1_a7 0.1276995674610439
LX0_b7 x0_m7 x0_n8 7.240277495153368e-10
LX1_b7 x1_m7 x1_n8 7.240277495153364e-10
KX01_b7 LX0_b7 LX1_b7 0.1276995674610439
CX0_g7 x0_m7 0 5.942475582044419e-13
CX01_7 x0_m7 x1_m7 3.947220550682456e-14
CX1_g7 x1_m7 0 5.942475582044421e-13
LX0_a8 x0_n8 x0_m8 7.240277495153368e-10
LX1_a8 x1_n8 x1_m8 7.240277495153364e-10
KX01_a8 LX0_a8 LX1_a8 0.1276995674610439
LX0_b8 x0_m8 x0_n9 7.240277495153368e-10
LX1_b8 x1_m8 x1_n9 7.240277495153364e-10
KX01_b8 LX0_b8 LX1_b8 0.1276995674610439
CX0_g8 x0_m8 0 5.942475582044419e-13
CX01_8 x0_m8 x1_m8 3.947220550682456e-14
CX1_g8 x1_m8 0 5.942475582044421e-13
LX0_a9 x0_n9 x0_m9 7.240277495153368e-10
LX1_a9 x1_n9 x1_m9 7.240277495153364e-10
KX01_a9 LX0_a9 LX1_a9 0.1276995674610439
LX0_b9 x0_m9 x0_n10 7.240277495153368e-10
LX1_b9 x1_m9 x1_n10 7.240277495153364e-10
KX01_b9 LX0_b9 LX1_b9 0.1276995674610439
CX0_g9 x0_m9 0 5.942475582044419e-13
CX01_9 x0_m9 x1_m9 3.947220550682456e-14
CX1_g9 x1_m9 0 5.942475582044421e-13
LX0_a10 x0_n10 x0_m10 7.240277495153368e-10
LX1_a10 x1_n10 x1_m10 7.240277495153364e-10
KX01_a10 LX0_a10 LX1_a10 0.1276995674610439
LX0_b10 x0_m10 x0_n11 7.240277495153368e-10
LX1_b10 x1_m10 x1_n11 7.240277495153364e-10
KX01_b10 LX0_b10 LX1_b10 0.1276995674610439
CX0_g10 x0_m10 0 5.942475582044419e-13
CX01_10 x0_m10 x1_m10 3.947220550682456e-14
CX1_g10 x1_m10 0 5.942475582044421e-13
LX0_a11 x0_n11 x0_m11 7.240277495153368e-10
LX1_a11 x1_n11 x1_m11 7.240277495153364e-10
KX01_a11 LX0_a11 LX1_a11 0.1276995674610439
LX0_b11 x0_m11 x0_n12 7.240277495153368e-10
LX1_b11 x1_m11 x1_n12 7.240277495153364e-10
KX01_b11 LX0_b11 LX1_b11 0.1276995674610439
CX0_g11 x0_m11 0 5.942475582044419e-13
CX01_11 x0_m11 x1_m11 3.947220550682456e-14
CX1_g11 x1_m11 0 5.942475582044421e-13
LX0_a12 x0_n12 x0_m12 7.240277495153368e-10
LX1_a12 x1_n12 x1_m12 7.240277495153364e-10
KX01_a12 LX0_a12 LX1_a12 0.1276995674610439
LX0_b12 x0_m12 x0_n13 7.240277495153368e-10
LX1_b12 x1_m12 x1_n13 7.240277495153364e-10
KX01_b12 LX0_b12 LX1_b12 0.1276995674610439
CX0_g12 x0_m12 0 5.942475582044419e-13
CX01_12 x0_m12 x1_m12 3.947220550682456e-14
CX1_g12 x1_m12 0 5.942475582044421e-13
LX0_a13 x0_n13 x0_m13 7.240277495153368e-10
LX1_a13 x1_n13 x1_m13 7.240277495153364e-10
KX01_a13 LX0_a13 LX1_a13 0.1276995674610439
LX0_b13 x0_m13 x0_n14 7.240277495153368e-10
LX1_b13 x1_m13 x1_n14 7.240277495153364e-10
KX01_b13 LX0_b13 LX1_b13 0.1276995674610439
CX0_g13 x0_m13 0 5.942475582044419e-13
CX01_13 x0_m13 x1_m13 3.947220550682456e-14
CX1_g13 x1_m13 0 5.942475582044421e-13
LX0_a14 x0_n14 x0_m14 7.240277495153368e-10
LX1_a14 x1_n14 x1_m14 7.240277495153364e-10
KX01_a14 LX0_a14 LX1_a14 0.1276995674610439
LX0_b14 x0_m14 x0_n15 7.240277495153368e-10
LX1_b14 x1_m14 x1_n15 7.240277495153364e-10
KX01_b14 LX0_b14 LX1_b14 0.1276995674610439
CX0_g14 x0_m14 0 5.942475582044419e-13
CX01_14 x0_m14 x1_m14 3.947220550682456e-14
CX1_g14 x1_m14 0 5.942475582044421e-13
LX0_a15 x0_n15 x0_m15 7.240277495153368e-10
LX1_a15 x1_n15 x1_m15 7.240277495153364e-10
KX01_a15 LX0_a15 LX1_a15 0.1276995674610439
LX0_b15 x0_m15 x0_n16 7.240277495153368e-10
LX1_b15 x1_m15 x1_n16 7.240277495153364e-10
KX01_b15 LX0_b15 LX1_b15 0.1276995674610439
CX0_g15 x0_m15 0 5.942475582044419e-13
CX01_15 x0_m15 x1_m15 3.947220550682456e-14
CX1_g15 x1_m15 0 5.942475582044421e-13
LX0_a16 x0_n16 x0_m16 7.240277495153368e-10
LX1_a16 x1_n16 x1_m16 7.240277495153364e-10
KX01_a16 LX0_a16 LX1_a16 0.1276995674610439
LX0_b16 x0_m16 x0_n17 7.240277495153368e-10
LX1_b16 x1_m16 x1_n17 7.240277495153364e-10
KX01_b16 LX0_b16 LX1_b16 0.1276995674610439
CX0_g16 x0_m16 0 5.942475582044419e-13
CX01_16 x0_m16 x1_m16 3.947220550682456e-14
CX1_g16 x1_m16 0 5.942475582044421e-13
LX0_a17 x0_n17 x0_m17 7.240277495153368e-10
LX1_a17 x1_n17 x1_m17 7.240277495153364e-10
KX01_a17 LX0_a17 LX1_a17 0.1276995674610439
LX0_b17 x0_m17 x0_n18 7.240277495153368e-10
LX1_b17 x1_m17 x1_n18 7.240277495153364e-10
KX01_b17 LX0_b17 LX1_b17 0.1276995674610439
CX0_g17 x0_m17 0 5.942475582044419e-13
CX01_17 x0_m17 x1_m17 3.947220550682456e-14
CX1_g17 x1_m17 0 5.942475582044421e-13
LX0_a18 x0_n18 x0_m18 7.240277495153368e-10
LX1_a18 x1_n18 x1_m18 7.240277495153364e-10
KX01_a18 LX0_a18 LX1_a18 0.1276995674610439
LX0_b18 x0_m18 x0_n19 7.240277495153368e-10
LX1_b18 x1_m18 x1_n19 7.240277495153364e-10
KX01_b18 LX0_b18 LX1_b18 0.1276995674610439
CX0_g18 x0_m18 0 5.942475582044419e-13
CX01_18 x0_m18 x1_m18 3.947220550682456e-14
CX1_g18 x1_m18 0 5.942475582044421e-13
LX0_a19 x0_n19 x0_m19 7.240277495153368e-10
LX1_a19 x1_n19 x1_m19 7.240277495153364e-10
KX01_a19 LX0_a19 LX1_a19 0.1276995674610439
LX0_b19 x0_m19 a_out 7.240277495153368e-10
LX1_b19 x1_m19 v_out 7.240277495153364e-10
KX01_b19 LX0_b19 LX1_b19 0.1276995674610439
CX0_g19 x0_m19 0 5.942475582044419e-13
CX01_19 x0_m19 x1_m19 3.947220550682456e-14
CX1_g19 x1_m19 0 5.942475582044421e-13
.ac lin 1 1e+08 1e+08
.end
