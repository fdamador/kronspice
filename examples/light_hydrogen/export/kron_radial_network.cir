Kron radial network (dual form)
LB0 n0 0 1
CV0 n0 0 1
CS0 n0 n1 49.99999999999999
LB1 n1 0 1
CV1 n1 0 6
CS1 n1 n2 49.99999999999999
LB2 n2 0 1
CV2 n2 0 7.666666666666671
CS2 n2 n3 49.99999999999999
LB3 n3 0 1
CV3 n3 0 8.5
CS3 n3 n4 49.99999999999999
LB4 n4 0 1
CV4 n4 0 9
CS4 n4 n5 49.99999999999999
LB5 n5 0 1
CV5 n5 0 9.333333333333329
CS5 n5 n6 49.99999999999999
LB6 n6 0 1
CV6 n6 0 9.57142857142857
CS6 n6 n7 49.99999999999999
LB7 n7 0 1
CV7 n7 0 9.75
CS7 n7 n8 49.99999999999999
LB8 n8 0 1
CV8 n8 0 9.888888888888886
CS8 n8 n9 49.99999999999999
LB9 n9 0 1
CV9 n9 0 10
CS9 n9 n10 49.99999999999999
LB10 n10 0 1
CV10 n10 0 10.090909090909093
CS10 n10 n11 49.99999999999999
LB11 n11 0 1
CV11 n11 0 10.166666666666671
CS11 n11 n12 49.99999999999999
LB12 n12 0 1
CV12 n12 0 10.230769230769226
CS12 n12 n13 49.99999999999999
LB13 n13 0 1
CV13 n13 0 10.285714285714292
CS13 n13 n14 49.99999999999999
LB14 n14 0 1
CV14 n14 0 10.333333333333329
CS14 n14 n15 49.99999999999999
LB15 n15 0 1
CV15 n15 0 10.375
CS15 n15 n16 49.99999999999999
LB16 n16 0 1
CV16 n16 0 10.411764705882348
CS16 n16 n17 49.99999999999999
LB17 n17 0 1
CV17 n17 0 10.444444444444443
CS17 n17 n18 49.99999999999999
LB18 n18 0 1
CV18 n18 0 10.473684210526315
CS18 n18 n19 49.99999999999999
LB19 n19 0 1
CV19 n19 0 10.5
CS19 n19 n20 49.99999999999999
LB20 n20 0 1
CV20 n20 0 10.523809523809518
CS20 n20 n21 49.99999999999999
LB21 n21 0 1
CV21 n21 0 10.545454545454547
CS21 n21 n22 49.99999999999999
LB22 n22 0 1
CV22 n22 0 10.565217391304344
CS22 n22 n23 49.99999999999999
LB23 n23 0 1
CV23 n23 0 10.583333333333329
CS23 n23 n24 49.99999999999999
LB24 n24 0 1
CV24 n24 0 10.599999999999994
CS24 n24 n25 49.99999999999999
LB25 n25 0 1
CV25 n25 0 10.615384615384613
CS25 n25 n26 49.99999999999999
LB26 n26 0 1
CV26 n26 0 10.629629629629633
CS26 n26 n27 49.99999999999999
LB27 n27 0 1
CV27 n27 0 10.642857142857139
CS27 n27 n28 49.99999999999999
LB28 n28 0 1
CV28 n28 0 10.65517241379311
CS28 n28 n29 49.99999999999999
LB29 n29 0 1
CV29 n29 0 10.666666666666671
CS29 n29 n30 49.99999999999999
LB30 n30 0 1
CV30 n30 0 10.677419354838705
CS30 n30 n31 49.99999999999999
LB31 n31 0 1
CV31 n31 0 10.6875
CS31 n31 n32 49.99999999999999
LB32 n32 0 1
CV32 n32 0 10.696969696969703
CS32 n32 n33 49.99999999999999
LB33 n33 0 1
CV33 n33 0 10.705882352941174
CS33 n33 n34 49.99999999999999
LB34 n34 0 1
CV34 n34 0 10.714285714285708
CS34 n34 n35 49.99999999999999
LB35 n35 0 1
CV35 n35 0 10.722222222222229
CS35 n35 n36 49.99999999999999
LB36 n36 0 1
CV36 n36 0 10.729729729729726
CS36 n36 n37 49.99999999999999
LB37 n37 0 1
CV37 n37 0 10.736842105263165
CS37 n37 n38 49.99999999999999
LB38 n38 0 1
CV38 n38 0 10.743589743589737
CS38 n38 n39 49.99999999999999
LB39 n39 0 1
CV39 n39 0 10.75
CS39 n39 n40 49.99999999999999
LB40 n40 0 1
CV40 n40 0 10.756097560975604
CS40 n40 n41 49.99999999999999
LB41 n41 0 1
CV41 n41 0 10.76190476190476
CS41 n41 n42 49.99999999999999
LB42 n42 0 1
CV42 n42 0 10.767441860465112
CS42 n42 n43 49.99999999999999
LB43 n43 0 1
CV43 n43 0 10.772727272727266
CS43 n43 n44 49.99999999999999
LB44 n44 0 1
CV44 n44 0 10.777777777777771
CS44 n44 n45 49.99999999999999
LB45 n45 0 1
CV45 n45 0 10.782608695652172
CS45 n45 n46 49.99999999999999
LB46 n46 0 1
CV46 n46 0 10.787234042553195
CS46 n46 n47 49.99999999999999
LB47 n47 0 1
CV47 n47 0 10.791666666666671
CS47 n47 n48 49.99999999999999
LB48 n48 0 1
CV48 n48 0 10.795918367346943
CS48 n48 n49 49.99999999999999
LB49 n49 0 1
CV49 n49 0 10.799999999999997
CS49 n49 n50 49.99999999999999
LB50 n50 0 1
CV50 n50 0 10.803921568627445
CS50 n50 n51 49.99999999999999
LB51 n51 0 1
CV51 n51 0 10.807692307692307
CS51 n51 n52 49.99999999999999
LB52 n52 0 1
CV52 n52 0 10.811320754716988
CS52 n52 n53 49.99999999999999
LB53 n53 0 1
CV53 n53 0 10.81481481481481
CS53 n53 n54 49.99999999999999
LB54 n54 0 1
CV54 n54 0 10.818181818181813
CS54 n54 n55 49.99999999999999
LB55 n55 0 1
CV55 n55 0 10.82142857142857
CS55 n55 n56 49.99999999999999
LB56 n56 0 1
CV56 n56 0 10.824561403508767
CS56 n56 n57 49.99999999999999
LB57 n57 0 1
CV57 n57 0 10.827586206896555
CS57 n57 n58 49.99999999999999
LB58 n58 0 1
CV58 n58 0 10.830508474576277
CS58 n58 n59 49.99999999999999
LB59 n59 0 1
CV59 n59 0 10.833333333333329
CS59 n59 n60 49.99999999999999
LB60 n60 0 1
CV60 n60 0 10.836065573770497
CS60 n60 n61 49.99999999999999
LB61 n61 0 1
CV61 n61 0 10.83870967741936
CS61 n61 n62 49.99999999999999
LB62 n62 0 1
CV62 n62 0 10.841269841269835
CS62 n62 n63 49.99999999999999
LB63 n63 0 1
CV63 n63 0 10.84375
CS63 n63 n64 49.99999999999999
LB64 n64 0 1
CV64 n64 0 10.84615384615384
CS64 n64 n65 49.99999999999999
LB65 n65 0 1
CV65 n65 0 10.848484848484844
CS65 n65 n66 49.99999999999999
LB66 n66 0 1
CV66 n66 0 10.85074626865672
CS66 n66 n67 49.99999999999999
LB67 n67 0 1
CV67 n67 0 10.852941176470594
CS67 n67 n68 49.99999999999999
LB68 n68 0 1
CV68 n68 0 10.85507246376811
CS68 n68 n69 49.99999999999999
LB69 n69 0 1
CV69 n69 0 10.857142857142861
CS69 n69 n70 49.99999999999999
LB70 n70 0 1
CV70 n70 0 10.859154929577471
CS70 n70 n71 49.99999999999999
LB71 n71 0 1
CV71 n71 0 10.861111111111114
CS71 n71 n72 49.99999999999999
LB72 n72 0 1
CV72 n72 0 10.86301369863014
CS72 n72 n73 49.99999999999999
LB73 n73 0 1
CV73 n73 0 10.86486486486487
CS73 n73 n74 49.99999999999999
LB74 n74 0 1
CV74 n74 0 10.86666666666666
CS74 n74 n75 49.99999999999999
LB75 n75 0 1
CV75 n75 0 10.868421052631575
CS75 n75 n76 49.99999999999999
LB76 n76 0 1
CV76 n76 0 10.870129870129873
CS76 n76 n77 49.99999999999999
LB77 n77 0 1
CV77 n77 0 10.871794871794876
CS77 n77 n78 49.99999999999999
LB78 n78 0 1
CV78 n78 0 10.87341772151899
CS78 n78 n79 49.99999999999999
LB79 n79 0 1
CV79 n79 0 10.875
CS79 n79 n80 49.99999999999999
LB80 n80 0 1
CV80 n80 0 10.876543209876544
CS80 n80 n81 49.99999999999999
LB81 n81 0 1
CV81 n81 0 10.878048780487802
CS81 n81 n82 49.99999999999999
LB82 n82 0 1
CV82 n82 0 10.879518072289159
CS82 n82 n83 49.99999999999999
LB83 n83 0 1
CV83 n83 0 10.88095238095238
CS83 n83 n84 49.99999999999999
LB84 n84 0 1
CV84 n84 0 10.882352941176464
CS84 n84 n85 49.99999999999999
LB85 n85 0 1
CV85 n85 0 10.883720930232556
CS85 n85 n86 49.99999999999999
LB86 n86 0 1
CV86 n86 0 10.885057471264375
CS86 n86 n87 49.99999999999999
LB87 n87 0 1
CV87 n87 0 10.88636363636364
CS87 n87 n88 49.99999999999999
LB88 n88 0 1
CV88 n88 0 10.887640449438209
CS88 n88 n89 49.99999999999999
LB89 n89 0 1
CV89 n89 0 10.888888888888886
CS89 n89 n90 49.99999999999999
LB90 n90 0 1
CV90 n90 0 10.890109890109883
CS90 n90 n91 49.99999999999999
LB91 n91 0 1
CV91 n91 0 10.891304347826093
CS91 n91 n92 49.99999999999999
LB92 n92 0 1
CV92 n92 0 10.892473118279568
CS92 n92 n93 49.99999999999999
LB93 n93 0 1
CV93 n93 0 10.893617021276597
CS93 n93 n94 49.99999999999999
LB94 n94 0 1
CV94 n94 0 10.89473684210526
CS94 n94 n95 49.99999999999999
LB95 n95 0 1
CV95 n95 0 10.895833333333329
CS95 n95 n96 49.99999999999999
LB96 n96 0 1
CV96 n96 0 10.896907216494839
CS96 n96 n97 49.99999999999999
LB97 n97 0 1
CV97 n97 0 10.897959183673464
CS97 n97 n98 49.99999999999999
LB98 n98 0 1
CV98 n98 0 10.898989898989896
CS98 n98 n99 49.99999999999999
LB99 n99 0 1
CV99 n99 0 10.900000000000006
CS99 n99 n100 49.99999999999999
LB100 n100 0 1
CV100 n100 0 10.900990099009903
CS100 n100 n101 49.99999999999999
LB101 n101 0 1
CV101 n101 0 10.90196078431373
CS101 n101 n102 49.99999999999999
LB102 n102 0 1
CV102 n102 0 10.90291262135922
CS102 n102 n103 49.99999999999999
LB103 n103 0 1
CV103 n103 0 10.90384615384616
CS103 n103 n104 49.99999999999999
LB104 n104 0 1
CV104 n104 0 10.904761904761898
CS104 n104 n105 49.99999999999999
LB105 n105 0 1
CV105 n105 0 10.905660377358487
CS105 n105 n106 49.99999999999999
LB106 n106 0 1
CV106 n106 0 10.90654205607477
CS106 n106 n107 49.99999999999999
LB107 n107 0 1
CV107 n107 0 10.907407407407405
CS107 n107 n108 49.99999999999999
LB108 n108 0 1
CV108 n108 0 10.908256880733944
CS108 n108 n109 49.99999999999999
LB109 n109 0 1
CV109 n109 0 10.909090909090907
CS109 n109 n110 49.99999999999999
LB110 n110 0 1
CV110 n110 0 10.909909909909913
CS110 n110 n111 49.99999999999999
LB111 n111 0 1
CV111 n111 0 10.910714285714292
CS111 n111 n112 49.99999999999999
LB112 n112 0 1
CV112 n112 0 10.911504424778755
CS112 n112 n113 49.99999999999999
LB113 n113 0 1
CV113 n113 0 10.912280701754383
CS113 n113 n114 49.99999999999999
LB114 n114 0 1
CV114 n114 0 10.913043478260875
CS114 n114 n115 49.99999999999999
LB115 n115 0 1
CV115 n115 0 10.91379310344827
CS115 n115 n116 49.99999999999999
LB116 n116 0 1
CV116 n116 0 10.914529914529908
CS116 n116 n117 49.99999999999999
LB117 n117 0 1
CV117 n117 0 10.915254237288138
CS117 n117 n118 49.99999999999999
LB118 n118 0 1
CV118 n118 0 10.915966386554615
CS118 n118 n119 49.99999999999999
LB119 n119 0 1
CV119 n119 0 10.916666666666671
CS119 n119 n120 49.99999999999999
LB120 n120 0 1
CV120 n120 0 10.917355371900825
CS120 n120 n121 49.99999999999999
LB121 n121 0 1
CV121 n121 0 10.918032786885249
CS121 n121 n122 49.99999999999999
LB122 n122 0 1
CV122 n122 0 10.918699186991873
CS122 n122 n123 49.99999999999999
LB123 n123 0 1
CV123 n123 0 10.91935483870968
CS123 n123 n124 49.99999999999999
LB124 n124 0 1
CV124 n124 0 10.920000000000002
CS124 n124 n125 49.99999999999999
LB125 n125 0 1
CV125 n125 0 10.920634920634924
CS125 n125 n126 49.99999999999999
LB126 n126 0 1
CV126 n126 0 10.921259842519689
CS126 n126 n127 49.99999999999999
LB127 n127 0 1
CV127 n127 0 10.921875
CS127 n127 n128 49.99999999999999
LB128 n128 0 1
CV128 n128 0 10.922480620155042
CS128 n128 n129 49.99999999999999
LB129 n129 0 1
CV129 n129 0 10.92307692307692
CS129 n129 n130 49.99999999999999
LB130 n130 0 1
CV130 n130 0 10.92366412213741
CS130 n130 n131 49.99999999999999
LB131 n131 0 1
CV131 n131 0 10.924242424242422
CS131 n131 n132 49.99999999999999
LB132 n132 0 1
CV132 n132 0 10.924812030075188
CS132 n132 n133 49.99999999999999
LB133 n133 0 1
CV133 n133 0 10.925373134328353
CS133 n133 n134 49.99999999999999
LB134 n134 0 1
CV134 n134 0 10.925925925925924
CS134 n134 n135 49.99999999999999
LB135 n135 0 1
CV135 n135 0 10.92647058823529
CS135 n135 n136 49.99999999999999
LB136 n136 0 1
CV136 n136 0 10.927007299270073
CS136 n136 n137 49.99999999999999
LB137 n137 0 1
CV137 n137 0 10.927536231884062
CS137 n137 n138 49.99999999999999
LB138 n138 0 1
CV138 n138 0 10.928057553956833
CS138 n138 n139 49.99999999999999
LB139 n139 0 1
CV139 n139 0 10.92857142857143
CS139 n139 n140 49.99999999999999
LB140 n140 0 1
CV140 n140 0 10.929078014184398
CS140 n140 n141 49.99999999999999
LB141 n141 0 1
CV141 n141 0 10.929577464788736
CS141 n141 n142 49.99999999999999
LB142 n142 0 1
CV142 n142 0 10.930069930069934
CS142 n142 n143 49.99999999999999
LB143 n143 0 1
CV143 n143 0 10.930555555555557
CS143 n143 n144 49.99999999999999
LB144 n144 0 1
CV144 n144 0 10.93103448275862
CS144 n144 n145 49.99999999999999
LB145 n145 0 1
CV145 n145 0 10.93150684931507
CS145 n145 n146 49.99999999999999
LB146 n146 0 1
CV146 n146 0 10.931972789115648
CS146 n146 n147 49.99999999999999
LB147 n147 0 1
CV147 n147 0 10.932432432432435
CS147 n147 n148 49.99999999999999
LB148 n148 0 1
CV148 n148 0 10.93288590604027
CS148 n148 n149 49.99999999999999
LB149 n149 0 1
CV149 n149 0 10.933333333333337
CS149 n149 n150 49.99999999999999
LB150 n150 0 1
CV150 n150 0 10.933774834437088
CS150 n150 n151 49.99999999999999
LB151 n151 0 1
CV151 n151 0 10.934210526315795
CS151 n151 n152 49.99999999999999
LB152 n152 0 1
CV152 n152 0 10.93464052287581
CS152 n152 n153 49.99999999999999
LB153 n153 0 1
CV153 n153 0 10.93506493506493
CS153 n153 n154 49.99999999999999
LB154 n154 0 1
CV154 n154 0 10.935483870967744
CS154 n154 n155 49.99999999999999
LB155 n155 0 1
CV155 n155 0 10.93589743589743
CS155 n155 n156 49.99999999999999
LB156 n156 0 1
CV156 n156 0 10.936305732484072
CS156 n156 n157 49.99999999999999
LB157 n157 0 1
CV157 n157 0 10.936708860759495
CS157 n157 n158 49.99999999999999
LB158 n158 0 1
CV158 n158 0 10.937106918238996
CS158 n158 n159 49.99999999999999
LB159 n159 0 1
CV159 n159 0 10.9375
CS159 n159 n160 49.99999999999999
LB160 n160 0 1
CV160 n160 0 10.937888198757761
CS160 n160 n161 49.99999999999999
LB161 n161 0 1
CV161 n161 0 10.938271604938265
CS161 n161 n162 49.99999999999999
LB162 n162 0 1
CV162 n162 0 10.938650306748471
CS162 n162 n163 49.99999999999999
LB163 n163 0 1
CV163 n163 0 10.939024390243901
CS163 n163 n164 49.99999999999999
LB164 n164 0 1
CV164 n164 0 10.939393939393938
CS164 n164 n165 49.99999999999999
LB165 n165 0 1
CV165 n165 0 10.93975903614458
CS165 n165 n166 49.99999999999999
LB166 n166 0 1
CV166 n166 0 10.940119760479035
CS166 n166 n167 49.99999999999999
LB167 n167 0 1
CV167 n167 0 10.94047619047619
CS167 n167 n168 49.99999999999999
LB168 n168 0 1
CV168 n168 0 10.940828402366861
CS168 n168 n169 49.99999999999999
LB169 n169 0 1
CV169 n169 0 10.941176470588232
CS169 n169 n170 49.99999999999999
LB170 n170 0 1
CV170 n170 0 10.941520467836256
CS170 n170 n171 49.99999999999999
LB171 n171 0 1
CV171 n171 0 10.941860465116278
CS171 n171 n172 49.99999999999999
LB172 n172 0 1
CV172 n172 0 10.942196531791907
CS172 n172 n173 49.99999999999999
LB173 n173 0 1
CV173 n173 0 10.94252873563218
CS173 n173 n174 49.99999999999999
LB174 n174 0 1
CV174 n174 0 10.942857142857136
CS174 n174 n175 49.99999999999999
LB175 n175 0 1
CV175 n175 0 10.943181818181813
CS175 n175 n176 49.99999999999999
LB176 n176 0 1
CV176 n176 0 10.943502824858754
CS176 n176 n177 49.99999999999999
LB177 n177 0 1
CV177 n177 0 10.943820224719104
CS177 n177 n178 49.99999999999999
LB178 n178 0 1
CV178 n178 0 10.944134078212286
CS178 n178 n179 49.99999999999999
LB179 n179 0 1
CV179 n179 0 10.944444444444443
CS179 n179 n180 49.99999999999999
LB180 n180 0 1
CV180 n180 0 10.944751381215468
CS180 n180 n181 49.99999999999999
LB181 n181 0 1
CV181 n181 0 10.945054945054949
CS181 n181 n182 49.99999999999999
LB182 n182 0 1
CV182 n182 0 10.945355191256837
CS182 n182 n183 49.99999999999999
LB183 n183 0 1
CV183 n183 0 10.945652173913047
CS183 n183 n184 49.99999999999999
LB184 n184 0 1
CV184 n184 0 10.945945945945951
CS184 n184 n185 49.99999999999999
LB185 n185 0 1
CV185 n185 0 10.946236559139791
CS185 n185 n186 49.99999999999999
LB186 n186 0 1
CV186 n186 0 10.946524064171129
CS186 n186 n187 49.99999999999999
LB187 n187 0 1
CV187 n187 0 10.946808510638292
CS187 n187 n188 49.99999999999999
LB188 n188 0 1
CV188 n188 0 10.94708994708995
CS188 n188 n189 49.99999999999999
LB189 n189 0 1
CV189 n189 0 10.94736842105263
CS189 n189 n190 49.99999999999999
LB190 n190 0 1
CV190 n190 0 10.947643979057588
CS190 n190 n191 49.99999999999999
LB191 n191 0 1
CV191 n191 0 10.947916666666671
CS191 n191 n192 49.99999999999999
LB192 n192 0 1
CV192 n192 0 10.948186528497416
CS192 n192 n193 49.99999999999999
LB193 n193 0 1
CV193 n193 0 10.94845360824742
CS193 n193 n194 49.99999999999999
LB194 n194 0 1
CV194 n194 0 10.948717948717942
CS194 n194 n195 49.99999999999999
LB195 n195 0 1
CV195 n195 0 10.948979591836732
CS195 n195 n196 49.99999999999999
LB196 n196 0 1
CV196 n196 0 10.949238578680209
CS196 n196 n197 49.99999999999999
LB197 n197 0 1
CV197 n197 0 10.949494949494948
CS197 n197 n198 49.99999999999999
LB198 n198 0 1
CV198 n198 0 10.949748743718587
CS198 n198 n199 49.99999999999999
LB199 n199 0 1
CV199 n199 0 10.950000000000003
CS199 n199 n200 49.99999999999999
LB200 n200 0 1
CV200 n200 0 10.950248756218912
CS200 n200 n201 49.99999999999999
LB201 n201 0 1
CV201 n201 0 10.950495049504951
CS201 n201 n202 49.99999999999999
LB202 n202 0 1
CV202 n202 0 10.950738916256157
CS202 n202 n203 49.99999999999999
LB203 n203 0 1
CV203 n203 0 10.950980392156865
CS203 n203 n204 49.99999999999999
LB204 n204 0 1
CV204 n204 0 10.951219512195124
CS204 n204 n205 49.99999999999999
LB205 n205 0 1
CV205 n205 0 10.951456310679617
CS205 n205 n206 49.99999999999999
LB206 n206 0 1
CV206 n206 0 10.951690821256037
CS206 n206 n207 49.99999999999999
LB207 n207 0 1
CV207 n207 0 10.95192307692308
CS207 n207 n208 49.99999999999999
LB208 n208 0 1
CV208 n208 0 10.952153110047846
CS208 n208 n209 49.99999999999999
LB209 n209 0 1
CV209 n209 0 10.952380952380949
CS209 n209 n210 49.99999999999999
LB210 n210 0 1
CV210 n210 0 10.952606635071092
CS210 n210 n211 49.99999999999999
LB211 n211 0 1
CV211 n211 0 10.952830188679243
CS211 n211 n212 49.99999999999999
LB212 n212 0 1
CV212 n212 0 10.953051643192495
CS212 n212 n213 49.99999999999999
LB213 n213 0 1
CV213 n213 0 10.953271028037378
CS213 n213 n214 49.99999999999999
LB214 n214 0 1
CV214 n214 0 10.95348837209302
CS214 n214 n215 49.99999999999999
LB215 n215 0 1
CV215 n215 0 10.95370370370371
CS215 n215 n216 49.99999999999999
LB216 n216 0 1
CV216 n216 0 10.953917050691246
CS216 n216 n217 49.99999999999999
LB217 n217 0 1
CV217 n217 0 10.954128440366972
CS217 n217 n218 49.99999999999999
LB218 n218 0 1
CV218 n218 0 10.954337899543376
CS218 n218 n219 49.99999999999999
LB219 n219 0 1
CV219 n219 0 10.954545454545453
CS219 n219 n220 49.99999999999999
LB220 n220 0 1
CV220 n220 0 10.954751131221713
CS220 n220 n221 49.99999999999999
LB221 n221 0 1
CV221 n221 0 10.954954954954957
CS221 n221 n222 49.99999999999999
LB222 n222 0 1
CV222 n222 0 10.955156950672645
CS222 n222 n223 49.99999999999999
LB223 n223 0 1
CV223 n223 0 10.955357142857139
CS223 n223 n224 49.99999999999999
LB224 n224 0 1
CV224 n224 0 10.955555555555549
CS224 n224 n225 49.99999999999999
LB225 n225 0 1
CV225 n225 0 10.955752212389385
CS225 n225 n226 49.99999999999999
LB226 n226 0 1
CV226 n226 0 10.955947136563879
CS226 n226 n227 49.99999999999999
LB227 n227 0 1
CV227 n227 0 10.956140350877192
CS227 n227 n228 49.99999999999999
LB228 n228 0 1
CV228 n228 0 10.956331877729255
CS228 n228 n229 49.99999999999999
LB229 n229 0 1
CV229 n229 0 10.956521739130437
CS229 n229 n230 49.99999999999999
LB230 n230 0 1
CV230 n230 0 10.956709956709958
CS230 n230 n231 49.99999999999999
LB231 n231 0 1
CV231 n231 0 10.956896551724142
CS231 n231 n232 49.99999999999999
LB232 n232 0 1
CV232 n232 0 10.957081545064383
CS232 n232 n233 49.99999999999999
LB233 n233 0 1
CV233 n233 0 10.957264957264954
CS233 n233 n234 49.99999999999999
LB234 n234 0 1
CV234 n234 0 10.957446808510639
CS234 n234 n235 49.99999999999999
LB235 n235 0 1
CV235 n235 0 10.95762711864407
CS235 n235 n236 49.99999999999999
LB236 n236 0 1
CV236 n236 0 10.957805907172997
CS236 n236 n237 49.99999999999999
LB237 n237 0 1
CV237 n237 0 10.957983193277315
CS237 n237 n238 49.99999999999999
LB238 n238 0 1
CV238 n238 0 10.958158995815893
CS238 n238 n239 49.99999999999999
LB239 n239 0 1
CV239 n239 0 10.958333333333329
CS239 n239 n240 49.99999999999999
LB240 n240 0 1
CV240 n240 0 10.958506224066383
CS240 n240 n241 49.99999999999999
LB241 n241 0 1
CV241 n241 0 10.95867768595042
CS241 n241 n242 49.99999999999999
LB242 n242 0 1
CV242 n242 0 10.958847736625515
CS242 n242 n243 49.99999999999999
LB243 n243 0 1
CV243 n243 0 10.959016393442624
CS243 n243 n244 49.99999999999999
LB244 n244 0 1
CV244 n244 0 10.959183673469383
CS244 n244 n245 49.99999999999999
LB245 n245 0 1
CV245 n245 0 10.95934959349593
CS245 n245 n246 49.99999999999999
LB246 n246 0 1
CV246 n246 0 10.959514170040492
CS246 n246 n247 49.99999999999999
LB247 n247 0 1
CV247 n247 0 10.959677419354833
CS247 n247 n248 49.99999999999999
LB248 n248 0 1
CV248 n248 0 10.959839357429715
CS248 n248 n249 49.99999999999999
LB249 n249 0 1
CV249 n249 0 10.959999999999994
CS249 n249 n250 49.99999999999999
LB250 n250 0 1
CV250 n250 0 10.960159362549803
CS250 n250 n251 49.99999999999999
LB251 n251 0 1
CV251 n251 0 10.960317460317455
CS251 n251 n252 49.99999999999999
LB252 n252 0 1
CV252 n252 0 10.960474308300391
CS252 n252 n253 49.99999999999999
LB253 n253 0 1
CV253 n253 0 10.960629921259837
CS253 n253 n254 49.99999999999999
LB254 n254 0 1
CV254 n254 0 10.960784313725483
CS254 n254 n255 49.99999999999999
LB255 n255 0 1
CV255 n255 0 10.9609375
CS255 n255 n256 49.99999999999999
LB256 n256 0 1
CV256 n256 0 10.961089494163417
CS256 n256 n257 49.99999999999999
LB257 n257 0 1
CV257 n257 0 10.961240310077514
CS257 n257 n258 49.99999999999999
LB258 n258 0 1
CV258 n258 0 10.961389961389955
CS258 n258 n259 49.99999999999999
LB259 n259 0 1
CV259 n259 0 10.961538461538467
CS259 n259 n260 49.99999999999999
LB260 n260 0 1
CV260 n260 0 10.961685823754792
CS260 n260 n261 49.99999999999999
LB261 n261 0 1
CV261 n261 0 10.961832061068705
CS261 n261 n262 49.99999999999999
LB262 n262 0 1
CV262 n262 0 10.961977186311785
CS262 n262 n263 49.99999999999999
LB263 n263 0 1
CV263 n263 0 10.962121212121218
CS263 n263 n264 49.99999999999999
LB264 n264 0 1
CV264 n264 0 10.962264150943398
CS264 n264 n265 49.99999999999999
LB265 n265 0 1
CV265 n265 0 10.962406015037601
CS265 n265 n266 49.99999999999999
LB266 n266 0 1
CV266 n266 0 10.962546816479403
CS266 n266 n267 49.99999999999999
LB267 n267 0 1
CV267 n267 0 10.962686567164184
CS267 n267 n268 49.99999999999999
LB268 n268 0 1
CV268 n268 0 10.962825278810413
CS268 n268 n269 49.99999999999999
LB269 n269 0 1
CV269 n269 0 10.962962962962962
CS269 n269 n270 49.99999999999999
LB270 n270 0 1
CV270 n270 0 10.963099630996311
CS270 n270 n271 49.99999999999999
LB271 n271 0 1
CV271 n271 0 10.963235294117652
CS271 n271 n272 49.99999999999999
LB272 n272 0 1
CV272 n272 0 10.963369963369956
CS272 n272 n273 49.99999999999999
LB273 n273 0 1
CV273 n273 0 10.96350364963503
CS273 n273 n274 49.99999999999999
LB274 n274 0 1
CV274 n274 0 10.963636363636368
CS274 n274 n275 49.99999999999999
LB275 n275 0 1
CV275 n275 0 10.963768115942031
CS275 n275 n276 49.99999999999999
LB276 n276 0 1
CV276 n276 0 10.963898916967509
CS276 n276 n277 49.99999999999999
LB277 n277 0 1
CV277 n277 0 10.964028776978424
CS277 n277 n278 49.99999999999999
LB278 n278 0 1
CV278 n278 0 10.96415770609319
CS278 n278 n279 49.99999999999999
LB279 n279 0 1
CV279 n279 0 10.964285714285708
CS279 n279 n280 49.99999999999999
LB280 n280 0 1
CV280 n280 0 10.964412811387902
CS280 n280 n281 49.99999999999999
LB281 n281 0 1
CV281 n281 0 10.964539007092199
CS281 n281 n282 49.99999999999999
LB282 n282 0 1
CV282 n282 0 10.964664310954063
CS282 n282 n283 49.99999999999999
LB283 n283 0 1
CV283 n283 0 10.964788732394368
CS283 n283 n284 49.99999999999999
LB284 n284 0 1
CV284 n284 0 10.964912280701753
CS284 n284 n285 49.99999999999999
LB285 n285 0 1
CV285 n285 0 10.96503496503496
CS285 n285 n286 49.99999999999999
LB286 n286 0 1
CV286 n286 0 10.965156794425084
CS286 n286 n287 49.99999999999999
LB287 n287 0 1
CV287 n287 0 10.965277777777771
CS287 n287 n288 49.99999999999999
LB288 n288 0 1
CV288 n288 0 10.965397923875429
CS288 n288 n289 49.99999999999999
LB289 n289 0 1
CV289 n289 0 10.965517241379317
CS289 n289 n290 49.99999999999999
LB290 n290 0 1
CV290 n290 0 10.965635738831608
CS290 n290 n291 49.99999999999999
LB291 n291 0 1
CV291 n291 0 10.965753424657535
CS291 n291 n292 49.99999999999999
LB292 n292 0 1
CV292 n292 0 10.965870307167236
CS292 n292 n293 49.99999999999999
LB293 n293 0 1
CV293 n293 0 10.965986394557817
CS293 n293 n294 49.99999999999999
LB294 n294 0 1
CV294 n294 0 10.966101694915253
CS294 n294 n295 49.99999999999999
LB295 n295 0 1
CV295 n295 0 10.96621621621621
CS295 n295 n296 49.99999999999999
LB296 n296 0 1
CV296 n296 0 10.966329966329965
CS296 n296 n297 49.99999999999999
LB297 n297 0 1
CV297 n297 0 10.966442953020135
CS297 n297 n298 49.99999999999999
LB298 n298 0 1
CV298 n298 0 10.966555183946483
CS298 n298 0 49.99999999999999
CS0G n0 0 49.99999999999999
IS 0 n9 DC 0 AC 1 0
.ac lin 1 0.0493518528124 0.0493518528124
.end
