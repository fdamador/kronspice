hydrogen hyperfine loops
LP np 0 2.702517627141861e-22
IP 0 np PWL(0 0 1e-09 101517.46250911764 2e-09 101517.46250911764)
LE0 ne0 0 1.1161457465548356e-18
IE0 0 ne0 PWL(0 0 1e-09 1.4792545979493377e-06 2e-09 1.4792545979493377e-06)
KE0 LP LE0 7.60397425393018e-07
LE1 ne1 0 2.0647382384964533e-18
IE1 0 ne1 PWL(0 0 1e-09 2.7732507749880857e-06 2e-09 2.7732507749880857e-06)
KE1 LP LE1 1.9131841682254996e-06
LE2 ne2 0 2.0647382384964533e-18
IE2 0 ne2 PWL(0 0 1e-09 2.7732507749880857e-06 2e-09 2.7732507749880857e-06)
KE2 LP LE2 1.9131841682254996e-06
LE3 ne3 0 1.1161457465548356e-18
IE3 0 ne3 PWL(0 0 1e-09 1.4792545979493377e-06 2e-09 1.4792545979493377e-06)
KE3 LP LE3 7.60397425393018e-07
LE4 ne4 0 3.5909684592953685e-18
IE4 0 ne4 PWL(0 0 1e-09 4.759196207932466e-06 2e-09 4.759196207932466e-06)
KE4 LP LE4 1.317676222075692e-07
LE5 ne5 0 6.642868921041556e-18
IE5 0 ne5 PWL(0 0 1e-09 8.922361701809693e-06 2e-09 8.922361701809693e-06)
KE5 LP LE5 3.3152930594808527e-07
LE6 ne6 0 6.642868921041556e-18
IE6 0 ne6 PWL(0 0 1e-09 8.922361701809693e-06 2e-09 8.922361701809693e-06)
KE6 LP LE6 3.3152930594808527e-07
LE7 ne7 0 3.5909684592953685e-18
IE7 0 ne7 PWL(0 0 1e-09 4.759196207932466e-06 2e-09 4.759196207932466e-06)
KE7 LP LE7 1.317676222075692e-07
LE8 ne8 0 6.480044669206513e-18
IE8 0 ne8 PWL(0 0 1e-09 8.588157865071335e-06 2e-09 8.588157865071335e-06)
KE8 LP LE8 5.435699372829103e-08
LE9 ne9 0 1.1987319807448152e-17
IE9 0 ne9 PWL(0 0 1e-09 1.6100754723389953e-05 2e-09 1.6100754723389953e-05)
KE9 LP LE9 1.367637947020751e-07
LE10 ne10 0 1.1987319807448152e-17
IE10 0 ne10 PWL(0 0 1e-09 1.6100754723389953e-05 2e-09 1.6100754723389953e-05)
KE10 LP LE10 1.367637947020751e-07
LE11 ne11 0 6.480044669206513e-18
IE11 0 ne11 PWL(0 0 1e-09 8.588157865071335e-06 2e-09 8.588157865071335e-06)
KE11 LP LE11 5.435699372829103e-08
LE12 ne12 0 9.950495173035796e-18
IE12 0 ne12 PWL(0 0 1e-09 1.3187628750115692e-05 2e-09 1.3187628750115692e-05)
KE12 LP LE12 2.8568552243976874e-08
LE13 ne13 0 1.8407244698246063e-17
IE13 0 ne13 PWL(0 0 1e-09 2.4723669409047904e-05 2e-09 2.4723669409047904e-05)
KE13 LP LE13 7.18738094079126e-08
LE14 ne14 0 1.8407244698246063e-17
IE14 0 ne14 PWL(0 0 1e-09 2.4723669409047904e-05 2e-09 2.4723669409047904e-05)
KE14 LP LE14 7.18738094079126e-08
LE15 ne15 0 9.950495173035796e-18
IE15 0 ne15 PWL(0 0 1e-09 1.3187628750115692e-05 2e-09 1.3187628750115692e-05)
KE15 LP LE15 2.8568552243976874e-08
LE16 ne16 0 1.4296791388526518e-17
IE16 0 ne16 PWL(0 0 1e-09 1.894787886141116e-05 2e-09 1.894787886141116e-05)
KE16 LP LE16 1.658672123956246e-08
LE17 ne17 0 2.644738105109756e-17
IE17 0 ne17 PWL(0 0 1e-09 3.5522769244478984e-05 2e-09 3.5522769244478984e-05)
KE17 LP LE17 4.173306848068258e-08
LE18 ne18 0 2.644738105109756e-17
IE18 0 ne18 PWL(0 0 1e-09 3.5522769244478984e-05 2e-09 3.5522769244478984e-05)
KE18 LP LE18 4.173306848068258e-08
LE19 ne19 0 1.4296791388526518e-17
IE19 0 ne19 PWL(0 0 1e-09 1.894787886141116e-05 2e-09 1.894787886141116e-05)
KE19 LP LE19 1.658672123956246e-08
LE20 ne20 0 2.0115828594818047e-17
IE20 0 ne20 PWL(0 0 1e-09 2.665998775903004e-05 2e-09 2.665998775903004e-05)
KE20 LP LE20 9.938424859508066e-09
LE21 ne21 0 3.721191486592352e-17
IE21 0 ne21 PWL(0 0 1e-09 4.998114037732069e-05 2e-09 4.998114037732069e-05)
KE21 LP LE21 2.5007377835182518e-08
LE22 ne22 0 3.721191486592352e-17
IE22 0 ne22 PWL(0 0 1e-09 4.998114037732069e-05 2e-09 4.998114037732069e-05)
KE22 LP LE22 2.5007377835182518e-08
LE23 ne23 0 2.0115828594818047e-17
IE23 0 ne23 PWL(0 0 1e-09 2.665998775903004e-05 2e-09 2.665998775903004e-05)
KE23 LP LE23 9.938424859508066e-09
LE24 ne24 0 2.8950178021299014e-17
IE24 0 ne24 PWL(0 0 1e-09 3.836836191119641e-05 2e-09 3.836836191119641e-05)
KE24 LP LE24 5.756335144984552e-09
LE25 ne25 0 5.355442132567314e-17
IE25 0 ne25 PWL(0 0 1e-09 7.193155901138053e-05 2e-09 7.193155901138053e-05)
KE25 LP LE25 1.448316913576632e-08
LE26 ne26 0 5.355442132567314e-17
IE26 0 ne26 PWL(0 0 1e-09 7.193155901138053e-05 2e-09 7.193155901138053e-05)
KE26 LP LE26 1.448316913576632e-08
LE27 ne27 0 2.8950178021299014e-17
IE27 0 ne27 PWL(0 0 1e-09 3.836836191119641e-05 2e-09 3.836836191119641e-05)
KE27 LP LE27 5.756335144984552e-09
LE28 ne28 0 4.794986086956223e-17
IE28 0 ne28 PWL(0 0 1e-09 6.35490950722771e-05 2e-09 6.35490950722771e-05)
KE28 LP LE28 2.7006758472287842e-09
LE29 ne29 0 8.870159795310022e-17
IE29 0 ne29 PWL(0 0 1e-09 0.00011913944861371314 2e-09 0.00011913944861371314)
KE29 LP LE29 6.794492195100738e-09
LE30 ne30 0 8.870159795310022e-17
IE30 0 ne30 PWL(0 0 1e-09 0.00011913944861371314 2e-09 0.00011913944861371314)
KE30 LP LE30 6.794492195100738e-09
LE31 ne31 0 4.794986086956223e-17
IE31 0 ne31 PWL(0 0 1e-09 6.35490950722771e-05 2e-09 6.35490950722771e-05)
KE31 LP LE31 2.7006758472287842e-09
.tran 10p 2n
.end
