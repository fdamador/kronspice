* Kron 1945 hydrogen s-wave ladder, dual LC form, h=0.25 a0, R=20.0 a0
* node n<i> voltage = u(r_i), r_i = i*h.  V0 = 4.100000
* 1s resonance on this grid: E = -0.49242250 Ha -> f = 0.083793879 Hz
* (E = 1/omega^2 - V0).  Run the .ac sweep and look for the driving-point pole.
I1 0 n4 AC 1
CB0 n1 0 8
CS1 n1 0 0.1
L1 n1 0 1
C1_2 n1 n2 8
CS2 n2 0 2.1
L2 n2 0 1
C2_3 n2 n3 8
CS3 n3 0 2.766666667
L3 n3 0 1
C3_4 n3 n4 8
CS4 n4 0 3.1
L4 n4 0 1
C4_5 n4 n5 8
CS5 n5 0 3.3
L5 n5 0 1
C5_6 n5 n6 8
CS6 n6 0 3.433333333
L6 n6 0 1
C6_7 n6 n7 8
CS7 n7 0 3.528571429
L7 n7 0 1
C7_8 n7 n8 8
CS8 n8 0 3.6
L8 n8 0 1
C8_9 n8 n9 8
CS9 n9 0 3.655555556
L9 n9 0 1
C9_10 n9 n10 8
CS10 n10 0 3.7
L10 n10 0 1
C10_11 n10 n11 8
CS11 n11 0 3.736363636
L11 n11 0 1
C11_12 n11 n12 8
CS12 n12 0 3.766666667
L12 n12 0 1
C12_13 n12 n13 8
CS13 n13 0 3.792307692
L13 n13 0 1
C13_14 n13 n14 8
CS14 n14 0 3.814285714
L14 n14 0 1
C14_15 n14 n15 8
CS15 n15 0 3.833333333
L15 n15 0 1
C15_16 n15 n16 8
CS16 n16 0 3.85
L16 n16 0 1
C16_17 n16 n17 8
CS17 n17 0 3.864705882
L17 n17 0 1
C17_18 n17 n18 8
CS18 n18 0 3.877777778
L18 n18 0 1
C18_19 n18 n19 8
CS19 n19 0 3.889473684
L19 n19 0 1
C19_20 n19 n20 8
CS20 n20 0 3.9
L20 n20 0 1
C20_21 n20 n21 8
CS21 n21 0 3.90952381
L21 n21 0 1
C21_22 n21 n22 8
CS22 n22 0 3.918181818
L22 n22 0 1
C22_23 n22 n23 8
CS23 n23 0 3.926086957
L23 n23 0 1
C23_24 n23 n24 8
CS24 n24 0 3.933333333
L24 n24 0 1
C24_25 n24 n25 8
CS25 n25 0 3.94
L25 n25 0 1
C25_26 n25 n26 8
CS26 n26 0 3.946153846
L26 n26 0 1
C26_27 n26 n27 8
CS27 n27 0 3.951851852
L27 n27 0 1
C27_28 n27 n28 8
CS28 n28 0 3.957142857
L28 n28 0 1
C28_29 n28 n29 8
CS29 n29 0 3.962068966
L29 n29 0 1
C29_30 n29 n30 8
CS30 n30 0 3.966666667
L30 n30 0 1
C30_31 n30 n31 8
CS31 n31 0 3.970967742
L31 n31 0 1
C31_32 n31 n32 8
CS32 n32 0 3.975
L32 n32 0 1
C32_33 n32 n33 8
CS33 n33 0 3.978787879
L33 n33 0 1
C33_34 n33 n34 8
CS34 n34 0 3.982352941
L34 n34 0 1
C34_35 n34 n35 8
CS35 n35 0 3.985714286
L35 n35 0 1
C35_36 n35 n36 8
CS36 n36 0 3.988888889
L36 n36 0 1
C36_37 n36 n37 8
CS37 n37 0 3.991891892
L37 n37 0 1
C37_38 n37 n38 8
CS38 n38 0 3.994736842
L38 n38 0 1
C38_39 n38 n39 8
CS39 n39 0 3.997435897
L39 n39 0 1
C39_40 n39 n40 8
CS40 n40 0 4
L40 n40 0 1
C40_41 n40 n41 8
CS41 n41 0 4.002439024
L41 n41 0 1
C41_42 n41 n42 8
CS42 n42 0 4.004761905
L42 n42 0 1
C42_43 n42 n43 8
CS43 n43 0 4.006976744
L43 n43 0 1
C43_44 n43 n44 8
CS44 n44 0 4.009090909
L44 n44 0 1
C44_45 n44 n45 8
CS45 n45 0 4.011111111
L45 n45 0 1
C45_46 n45 n46 8
CS46 n46 0 4.013043478
L46 n46 0 1
C46_47 n46 n47 8
CS47 n47 0 4.014893617
L47 n47 0 1
C47_48 n47 n48 8
CS48 n48 0 4.016666667
L48 n48 0 1
C48_49 n48 n49 8
CS49 n49 0 4.018367347
L49 n49 0 1
C49_50 n49 n50 8
CS50 n50 0 4.02
L50 n50 0 1
C50_51 n50 n51 8
CS51 n51 0 4.021568627
L51 n51 0 1
C51_52 n51 n52 8
CS52 n52 0 4.023076923
L52 n52 0 1
C52_53 n52 n53 8
CS53 n53 0 4.024528302
L53 n53 0 1
C53_54 n53 n54 8
CS54 n54 0 4.025925926
L54 n54 0 1
C54_55 n54 n55 8
CS55 n55 0 4.027272727
L55 n55 0 1
C55_56 n55 n56 8
CS56 n56 0 4.028571429
L56 n56 0 1
C56_57 n56 n57 8
CS57 n57 0 4.029824561
L57 n57 0 1
C57_58 n57 n58 8
CS58 n58 0 4.031034483
L58 n58 0 1
C58_59 n58 n59 8
CS59 n59 0 4.03220339
L59 n59 0 1
C59_60 n59 n60 8
CS60 n60 0 4.033333333
L60 n60 0 1
C60_61 n60 n61 8
CS61 n61 0 4.03442623
L61 n61 0 1
C61_62 n61 n62 8
CS62 n62 0 4.035483871
L62 n62 0 1
C62_63 n62 n63 8
CS63 n63 0 4.036507937
L63 n63 0 1
C63_64 n63 n64 8
CS64 n64 0 4.0375
L64 n64 0 1
C64_65 n64 n65 8
CS65 n65 0 4.038461538
L65 n65 0 1
C65_66 n65 n66 8
CS66 n66 0 4.039393939
L66 n66 0 1
C66_67 n66 n67 8
CS67 n67 0 4.040298507
L67 n67 0 1
C67_68 n67 n68 8
CS68 n68 0 4.041176471
L68 n68 0 1
C68_69 n68 n69 8
CS69 n69 0 4.042028986
L69 n69 0 1
C69_70 n69 n70 8
CS70 n70 0 4.042857143
L70 n70 0 1
C70_71 n70 n71 8
CS71 n71 0 4.043661972
L71 n71 0 1
C71_72 n71 n72 8
CS72 n72 0 4.044444444
L72 n72 0 1
C72_73 n72 n73 8
CS73 n73 0 4.045205479
L73 n73 0 1
C73_74 n73 n74 8
CS74 n74 0 4.045945946
L74 n74 0 1
C74_75 n74 n75 8
CS75 n75 0 4.046666667
L75 n75 0 1
C75_76 n75 n76 8
CS76 n76 0 4.047368421
L76 n76 0 1
C76_77 n76 n77 8
CS77 n77 0 4.048051948
L77 n77 0 1
C77_78 n77 n78 8
CS78 n78 0 4.048717949
L78 n78 0 1
C78_79 n78 n79 8
CS79 n79 0 4.049367089
L79 n79 0 1
CB1 n79 0 8
.ac lin 2001 0.0833749099 0.0842128487
.print ac vm(n4)
.end
