torn GA: RC pre-filter into a fixed line
V1 in 0 AC 1
R1 in m 1k
C1 m 0 10n
R2 m f 1k
C2 f 0 10n
RT f p0 10
RP0 p0 q0 1
LP0 q0 p1 1u
CP0 p1 0 1n
RP1 p1 q1 1
LP1 q1 p2 1u
CP1 p2 0 1n
RP2 p2 q2 1
LP2 q2 p3 1u
CP2 p3 0 1n
RP3 p3 q3 1
LP3 q3 p4 1u
CP3 p4 0 1n
RP4 p4 q4 1
LP4 q4 p5 1u
CP4 p5 0 1n
RP5 p5 q5 1
LP5 q5 p6 1u
CP5 p6 0 1n
RP6 p6 q6 1
LP6 q6 p7 1u
CP6 p7 0 1n
RP7 p7 q7 1
LP7 q7 p8 1u
CP7 p8 0 1n
RP8 p8 q8 1
LP8 q8 p9 1u
CP8 p9 0 1n
RP9 p9 q9 1
LP9 q9 p10 1u
CP9 p10 0 1n
RP10 p10 q10 1
LP10 q10 p11 1u
CP10 p11 0 1n
RP11 p11 q11 1
LP11 q11 p12 1u
CP11 p12 0 1n
RP12 p12 q12 1
LP12 q12 p13 1u
CP12 p13 0 1n
RP13 p13 q13 1
LP13 q13 p14 1u
CP13 p14 0 1n
RP14 p14 q14 1
LP14 q14 p15 1u
CP14 p15 0 1n
RP15 p15 q15 1
LP15 q15 p16 1u
CP15 p16 0 1n
RP16 p16 q16 1
LP16 q16 p17 1u
CP16 p17 0 1n
RP17 p17 q17 1
LP17 q17 p18 1u
CP17 p18 0 1n
RP18 p18 q18 1
LP18 q18 p19 1u
CP18 p19 0 1n
RP19 p19 q19 1
LP19 q19 p20 1u
CP19 p20 0 1n
RP20 p20 q20 1
LP20 q20 p21 1u
CP20 p21 0 1n
RP21 p21 q21 1
LP21 q21 p22 1u
CP21 p22 0 1n
RP22 p22 q22 1
LP22 q22 p23 1u
CP22 p23 0 1n
RP23 p23 q23 1
LP23 q23 p24 1u
CP23 p24 0 1n
RP24 p24 q24 1
LP24 q24 p25 1u
CP24 p25 0 1n
RP25 p25 q25 1
LP25 q25 p26 1u
CP25 p26 0 1n
RP26 p26 q26 1
LP26 q26 p27 1u
CP26 p27 0 1n
RP27 p27 q27 1
LP27 q27 p28 1u
CP27 p28 0 1n
RP28 p28 q28 1
LP28 q28 p29 1u
CP28 p29 0 1n
RP29 p29 q29 1
LP29 q29 p30 1u
CP29 p30 0 1n
RP30 p30 q30 1
LP30 q30 p31 1u
CP30 p31 0 1n
RP31 p31 q31 1
LP31 q31 p32 1u
CP31 p32 0 1n
RP32 p32 q32 1
LP32 q32 p33 1u
CP32 p33 0 1n
RP33 p33 q33 1
LP33 q33 p34 1u
CP33 p34 0 1n
RP34 p34 q34 1
LP34 q34 p35 1u
CP34 p35 0 1n
RP35 p35 q35 1
LP35 q35 p36 1u
CP35 p36 0 1n
RP36 p36 q36 1
LP36 q36 p37 1u
CP36 p37 0 1n
RP37 p37 q37 1
LP37 q37 p38 1u
CP37 p38 0 1n
RP38 p38 q38 1
LP38 q38 p39 1u
CP38 p39 0 1n
RP39 p39 q39 1
LP39 q39 out 1u
CP39 out 0 1n
RL out 0 31.6
.ac dec 50 100 1meg
.end
