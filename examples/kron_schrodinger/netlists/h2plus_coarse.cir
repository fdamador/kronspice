Kron 1945 Schrodinger network (dual form), 1950 junctions
* psi = junction voltage; omega^2 = 1/(E + V0), V0 = 5.08769153631 Ha (examples/kron_schrodinger)
CV0 n0 0 0.986100356883512
LB0 n0 0 5
CV1 n1 0 2.95839584482796
LB1 n1 0 1.66666666666667
CV2 n2 0 4.93097419904232
LB2 n2 0 1
CV3 n3 0 6.904019195824
LB3 n3 0 0.714285714285714
CV4 n4 0 8.87770759161338
LB4 n4 0 0.555555555555556
CV5 n5 0 10.8522066667316
LB5 n5 0 0.454545454545455
CV6 n6 0 12.8276720934954
LB6 n6 0 0.384615384615385
CV7 n7 0 14.8042461854983
LB7 n7 0 0.333333333333333
CV8 n8 0 16.782056562892
LB8 n8 0 0.294117647058823
CV9 n9 0 18.7612152462882
LB9 n9 0 0.263157894736842
CV10 n10 0 20.74181817118
LB10 n10 0 0.238095238095238
CV11 n11 0 22.7239450969287
LB11 n11 0 0.217391304347826
CV12 n12 0 24.7076598703008
LB12 n12 0 0.2
CV13 n13 0 26.6930109937169
LB13 n13 0 0.185185185185185
CV14 n14 0 28.6800324427763
LB14 n14 0 0.172413793103448
CV15 n15 0 30.6687446758896
LB15 n15 0 0.161290322580645
CV16 n16 0 32.6591557803718
LB16 n16 0 0.151515151515151
CV17 n17 0 34.6512627033892
LB17 n17 0 0.142857142857143
CV18 n18 0 36.6450525219311
LB18 n18 0 0.135135135135135
CV19 n19 0 38.6405037127773
LB19 n19 0 0.128205128205128
CV20 n20 0 40.6375873906265
LB20 n20 0 0.121951219512195
CV21 n21 0 42.6362684896416
LB21 n21 0 0.116279069767442
CV22 n22 0 44.6365068702921
LB22 n22 0 0.111111111111111
CV23 n23 0 46.6382583392959
LB23 n23 0 0.106382978723404
CV24 n24 0 48.6414755755454
LB24 n24 0 0.102040816326531
CV25 n25 0 50.6461089591154
LB25 n25 0 0.0980392156862745
CV26 n26 0 52.6521073037957
LB26 n26 0 0.0943396226415094
CV27 n27 0 54.6594184961522
LB27 n27 0 0.0909090909090909
CV28 n28 0 56.6679900459739
LB28 n28 0 0.087719298245614
CV29 n29 0 58.6777695542151
LB29 n29 0 0.0847457627118644
CV30 n30 0 0.985073435901757
LB30 n30 0 5
CV31 n31 0 2.95532478771761
LB31 n31 0 1.66666666666667
CV32 n32 0 4.92588786377051
LB32 n32 0 1
CV33 n33 0 6.89696482766358
LB33 n33 0 0.714285714285714
CV34 n34 0 8.86874959316585
LB34 n34 0 0.555555555555556
CV35 n35 0 10.8414249657908
LB35 n35 0 0.454545454545455
CV36 n36 0 12.8151601892738
LB36 n36 0 0.384615384615385
CV37 n37 0 14.7901089647906
LB37 n37 0 0.333333333333333
CV38 n38 0 16.7664079819274
LB38 n38 0 0.294117647058823
CV39 n39 0 18.7441759716749
LB39 n39 0 0.263157894736842
CV40 n40 0 20.7235132654166
LB40 n40 0 0.238095238095238
CV41 n41 0 22.7045018218086
LB41 n41 0 0.217391304347826
CV42 n42 0 24.6872056667239
LB42 n42 0 0.2
CV43 n43 0 26.6716716804672
LB43 n43 0 0.185185185185185
CV44 n44 0 28.6579306610776
LB44 n44 0 0.172413793103448
CV45 n45 0 30.6459985920765
LB45 n45 0 0.161290322580645
CV46 n46 0 32.6358780465353
LB46 n46 0 0.151515151515151
CV47 n47 0 34.6275596657801
LB47 n47 0 0.142857142857143
CV48 n48 0 36.6210236593514
LB48 n48 0 0.135135135135135
CV49 n49 0 38.6162412820522
LB49 n49 0 0.128205128205128
CV50 n50 0 40.613176253279
LB50 n50 0 0.121951219512195
CV51 n51 0 42.6117860927339
LB51 n51 0 0.116279069767442
CV52 n52 0 44.6120233546841
LB52 n52 0 0.111111111111111
CV53 n53 0 46.6138367499166
LB53 n53 0 0.106382978723404
CV54 n54 0 48.6171721503515
LB54 n54 0 0.102040816326531
CV55 n55 0 50.6219734759186
LB55 n55 0 0.0980392156862745
CV56 n56 0 52.6281834668542
LB56 n56 0 0.0943396226415094
CV57 n57 0 54.6357443471554
LB57 n57 0 0.0909090909090909
CV58 n58 0 56.6445983866746
LB58 n58 0 0.087719298245614
CV59 n59 0 58.6546883703981
LB59 n59 0 0.0847457627118644
CV60 n60 0 0.983976698550676
LB60 n60 0 5
CV61 n61 0 2.95204566201592
LB61 n61 0 1.66666666666667
CV62 n62 0 4.92045929137972
LB62 n62 0 1
CV63 n63 0 6.8894406714359
LB63 n63 0 0.714285714285714
CV64 n64 0 8.85920313876667
LB64 n64 0 0.555555555555556
CV65 n65 0 10.8299469410443
LB65 n65 0 0.454545454545455
CV66 n66 0 12.801856405331
LB66 n66 0 0.384615384615385
CV67 n67 0 14.7750976964301
LB67 n67 0 0.333333333333333
CV68 n68 0 16.7498172082009
LB68 n68 0 0.294117647058823
CV69 n69 0 18.7261405933556
LB69 n69 0 0.263157894736842
CV70 n70 0 20.7041724037739
LB70 n70 0 0.238095238095238
CV71 n71 0 22.6839962861308
LB71 n71 0 0.217391304347826
CV72 n72 0 24.6656756579248
LB72 n72 0 0.2
CV73 n73 0 26.6492547771351
LB73 n73 0 0.185185185185185
CV74 n74 0 28.6347601142159
LB74 n74 0 0.172413793103448
CV75 n75 0 30.6222019368522
LB75 n75 0 0.161290322580645
CV76 n76 0 32.6115760244213
LB76 n76 0 0.151515151515151
CV77 n77 0 34.6028654389207
LB77 n77 0 0.142857142857143
CV78 n78 0 36.5960422908003
LB78 n78 0 0.135135135135135
CV79 n79 0 38.591069450459
LB79 n79 0 0.128205128205128
CV80 n80 0 40.5879021681888
LB80 n80 0 0.121951219512195
CV81 n81 0 42.5864895764048
LB81 n81 0 0.116279069767442
CV82 n82 0 44.5867760576752
LB82 n82 0 0.111111111111111
CV83 n83 0 46.5887024701739
LB83 n83 0 0.106382978723404
CV84 n84 0 48.5922072286774
LB84 n84 0 0.102040816326531
CV85 n85 0 50.5972272442198
LB85 n85 0 0.0980392156862745
CV86 n86 0 52.6036987291404
LB86 n86 0 0.0943396226415094
CV87 n87 0 54.611557876724
LB87 n87 0 0.0909090909090909
CV88 n88 0 56.6207414261291
LB88 n88 0 0.087719298245614
CV89 n89 0 58.6311871240363
LB89 n89 0 0.0847457627118644
CV90 n90 0 0.982802723687058
LB90 n90 0 5
CV91 n91 0 2.94853646034608
LB91 n91 0 1.66666666666667
CV92 n92 0 4.91465264071319
LB92 n92 0 1
CV93 n93 0 6.88139825550039
LB93 n93 0 0.714285714285714
CV94 n94 0 8.84900870945927
LB94 n94 0 0.555555555555556
CV95 n95 0 10.8177038995624
LB95 n95 0 0.454545454545455
CV96 n96 0 12.7876849378726
LB96 n96 0 0.384615384615385
CV97 n97 0 14.7591316158155
LB97 n97 0 0.333333333333333
CV98 n98 0 16.7322006557276
LB98 n98 0 0.294117647058823
CV99 n99 0 18.7070247466165
LB99 n99 0 0.263157894736842
CV100 n100 0 20.6837123183635
LB100 n100 0 0.238095238095238
CV101 n101 0 22.6623479750867
LB101 n101 0 0.217391304347826
CV102 n102 0 24.6429934855165
LB102 n102 0 0.2
CV103 n103 0 26.6256892160596
LB103 n103 0 0.185185185185185
CV104 n104 0 28.6104558896629
LB104 n104 0 0.172413793103448
CV105 n105 0 30.597296558846
LB105 n105 0 0.161290322580645
CV106 n106 0 32.5861986922105
LB106 n106 0 0.151515151515151
CV107 n107 0 34.5771362882285
LB107 n107 0 0.142857142857143
CV108 n108 0 36.5700719462507
LB108 n108 0 0.135135135135135
CV109 n109 0 38.5649588409309
LB109 n109 0 0.128205128205128
CV110 n110 0 40.5617425615089
LB110 n110 0 0.121951219512195
CV111 n111 0 42.5603627909189
LB111 n111 0 0.116279069767442
CV112 n112 0 44.5607548111077
LB112 n112 0 0.111111111111111
CV113 n113 0 46.5628508301571
LB113 n113 0 0.106382978723404
CV114 n114 0 48.5665811338878
LB114 n114 0 0.102040816326531
CV115 n115 0 50.5718750697814
LB115 n115 0 0.0980392156862745
CV116 n116 0 52.578661874558
LB116 n116 0 0.0943396226415094
CV117 n117 0 54.5868713588955
LB117 n117 0 0.0909090909090909
CV118 n118 0 56.5964344638356
LB118 n118 0 0.087719298245614
CV119 n119 0 58.6072837036689
LB119 n119 0 0.0847457627118644
CV120 n120 0 0.981542992087649
LB120 n120 0 5
CV121 n121 0 2.94477194063292
LB121 n121 0 1.66666666666667
CV122 n122 0 4.90842687283033
LB122 n122 0 1
CV123 n123 0 6.87278222025247
LB123 n123 0 0.714285714285714
CV124 n124 0 8.83809855812924
LB124 n124 0 0.555555555555556
CV125 n125 0 10.8046179798863
LB125 n125 0 0.454545454545455
CV126 n126 0 12.7725602947814
LB126 n126 0 0.384615384615385
CV127 n127 0 14.7421201636743
LB127 n127 0 0.333333333333333
CV128 n128 0 16.7134652196386
LB128 n128 0 0.294117647058823
CV129 n129 0 18.6867351557497
LB129 n129 0 0.263157894736842
CV130 n130 0 20.6620417078385
LB130 n130 0 0.238095238095238
CV131 n131 0 22.6394694190355
LB131 n131 0 0.217391304347826
CV132 n132 0 24.619077047028
LB132 n132 0 0.2
CV133 n133 0 26.6008994635809
LB133 n133 0 0.185185185185185
CV134 n134 0 28.5849498970238
LB134 n134 0 0.172413793103448
CV135 n135 0 30.5712223792204
LB135 n135 0 0.161290322580645
CV136 n136 0 32.5596942758678
LB136 n136 0 0.151515151515151
CV137 n137 0 34.5503287998663
LB137 n137 0 0.142857142857143
CV138 n138 0 36.5430774294559
LB138 n138 0 0.135135135135135
CV139 n139 0 38.5378821739555
LB139 n139 0 0.128205128205128
CV140 n140 0 40.5346776489984
LB140 n140 0 0.121951219512195
CV141 n141 0 42.5333929394142
LB141 n141 0 0.116279069767442
CV142 n142 0 44.5339532411057
LB142 n142 0 0.111111111111111
CV143 n143 0 46.5362812834503
LB143 n143 0 0.106382978723404
CV144 n144 0 48.5402985411867
LB144 n144 0 0.102040816326531
CV145 n145 0 50.5459262498051
LB145 n145 0 0.0980392156862745
CV146 n146 0 52.5530862415551
LB146 n146 0 0.0943396226415094
CV147 n147 0 54.5617016207413
LB147 n147 0 0.0909090909090909
CV148 n148 0 56.5716972973671
LB148 n148 0 0.087719298245614
CV149 n149 0 58.5830003977363
LB149 n149 0 0.0847457627118644
CV150 n150 0 0.980187674055588
LB150 n150 0 5
CV151 n151 0 2.94072300582477
LB151 n151 0 1.66666666666667
CV152 n152 0 4.9017347716074
LB152 n152 0 1
CV153 n153 0 6.86352905471417
LB153 n153 0 0.714285714285714
CV154 n154 0 8.82639525535281
LB154 n154 0 0.555555555555556
CV155 n155 0 10.7906006089519
LB155 n155 0 0.454545454545455
CV156 n156 0 12.756385764337
LB156 n156 0 0.384615384615385
CV157 n157 0 14.7239615577352
LB157 n157 0 0.333333333333333
CV158 n158 0 16.6935070260065
LB158 n158 0 0.294117647058823
CV159 n159 0 18.6651686173862
LB159 n159 0 0.263157894736842
CV160 n160 0 20.6390604883835
LB160 n160 0 0.238095238095238
CV161 n161 0 22.6152657259317
LB161 n161 0 0.217391304347826
CV162 n162 0 24.5938383056629
LB162 n162 0 0.2
CV163 n163 0 26.5748055886502
LB163 n163 0 0.185185185185185
CV164 n164 0 28.5581711665921
LB164 n164 0 0.172413793103448
CV165 n165 0 30.5439178847262
LB165 n165 0 0.161290322580645
CV166 n166 0 32.5320108981968
LB166 n166 0 0.151515151515151
CV167 n167 0 34.5224006471148
LB167 n167 0 0.142857142857143
CV168 n168 0 36.5150256649589
LB168 n168 0 0.135135135135135
CV169 n169 0 38.5098151620386
LB169 n169 0 0.128205128205128
CV170 n170 0 40.5066913491473
LB170 n170 0 0.121951219512195
CV171 n171 0 42.5055714856713
LB171 n171 0 0.116279069767442
CV172 n172 0 44.5063696512624
LB172 n172 0 0.111111111111111
CV173 n173 0 46.5089982510287
LB173 n173 0 0.106382978723404
CV174 n174 0 48.5133692715944
LB174 n174 0 0.102040816326531
CV175 n175 0 50.5193953099118
LB175 n175 0 0.0980392156862745
CV176 n176 0 52.5269903990131
LB176 n176 0 0.0943396226415094
CV177 n177 0 54.5360706555007
LB177 n177 0 0.0909090909090909
CV178 n178 0 56.5465547729992
LB178 n178 0 0.087719298245614
CV179 n179 0 58.5583643844068
LB179 n179 0 0.0847457627118644
CV180 n180 0 0.978725365384679
LB180 n180 0 5
CV181 n181 0 2.93635593443608
LB181 n181 0 1.66666666666667
CV182 n182 0 4.89452173399861
LB182 n182 0 1
CV183 n183 0 6.85356554621578
LB183 n183 0 0.714285714285714
CV184 n184 0 8.81380992109169
LB184 n184 0 0.555555555555556
CV185 n185 0 10.7755506477963
LB185 n185 0 0.454545454545455
CV186 n186 0 12.7390516030907
LB186 n186 0 0.384615384615385
CV187 n187 0 14.7045411358481
LB187 n187 0 0.333333333333333
CV188 n188 0 16.6722100201552
LB188 n188 0 0.294117647058823
CV189 n189 0 18.6422108964522
LB189 n189 0 0.263157894736842
CV190 n190 0 20.6146590314719
LB190 n190 0 0.238095238095238
CV191 n191 0 22.5896341688391
LB191 n191 0 0.217391304347826
CV192 n192 0 24.5671832134715
LB192 n192 0 0.2
CV193 n193 0 26.5473234907503
LB193 n193 0 0.185185185185185
CV194 n194 0 28.5300463398133
LB194 n194 0 0.172413793103448
CV195 n195 0 30.5153208323661
LB195 n195 0 0.161290322580645
CV196 n196 0 32.5030974476084
LB196 n196 0 0.151515151515151
CV197 n197 0 34.4933115748143
LB197 n197 0 0.142857142857143
CV198 n198 0 36.4858867538543
LB198 n198 0 0.135135135135135
CV199 n199 0 38.4807375980051
LB199 n199 0 0.128205128205128
CV200 n200 0 40.4777723715342
LB200 n200 0 0.121951219512195
CV201 n201 0 42.4768952164704
LB201 n201 0 0.116279069767442
CV202 n202 0 44.4780080390578
LB202 n202 0 0.111111111111111
CV203 n203 0 46.4810120773497
LB203 n203 0 0.106382978723404
CV204 n204 0 48.485809178149
LB204 n204 0 0.102040816326531
CV205 n205 0 50.4923028149325
LB205 n205 0 0.0980392156862745
CV206 n206 0 52.5003988793811
LB206 n206 0 0.0943396226415094
CV207 n207 0 54.510006278373
LB207 n207 0 0.0909090909090909
CV208 n208 0 56.5210373664
LB208 n208 0 0.087719298245614
CV209 n209 0 58.5334082407818
LB209 n209 0 0.0847457627118644
CV210 n210 0 0.977142756308733
LB210 n210 0 5
CV211 n211 0 2.93163141810054
LB211 n211 0 1.66666666666667
CV212 n212 0 4.88672426418961
LB212 n212 0 1
CV213 n213 0 6.84280686487398
LB213 n213 0 0.714285714285714
CV214 n214 0 8.80024006210383
LB214 n214 0 0.555555555555556
CV215 n215 0 10.7593521542602
LB215 n215 0 0.454545454545455
CV216 n216 0 12.7204328876484
LB216 n216 0 0.384615384615385
CV217 n217 0 14.683729437112
LB217 n217 0 0.333333333333333
CV218 n218 0 16.6494443838759
LB218 n218 0 0.294117647058823
CV219 n219 0 18.6177355481281
LB219 n219 0 0.263157894736842
CV220 n220 0 20.5887174215261
LB220 n220 0 0.238095238095238
CV221 n221 0 22.5624638767805
LB221 n221 0 0.217391304347826
CV222 n222 0 24.5390118060551
LB222 n222 0 0.2
CV223 n223 0 26.5183653499907
LB223 n223 0 0.185185185185185
CV224 n224 0 28.5005004147794
LB224 n224 0 0.172413793103448
CV225 n225 0 30.4853692254824
LB225 n225 0 0.161290322580645
CV226 n226 0 32.472904720571
LB226 n226 0 0.151515151515151
CV227 n227 0 34.4630246484408
LB227 n227 0 0.142857142857143
CV228 n228 0 36.4556352767627
LB228 n228 0 0.135135135135135
CV229 n229 0 38.4506346674686
LB229 n229 0 0.128205128205128
CV230 n230 0 40.4479155030789
LB230 n230 0 0.121951219512195
CV231 n231 0 42.4473674742961
LB231 n231 0 0.116279069767442
CV232 n232 0 44.448879255319
LB232 n232 0 0.111111111111111
CV233 n233 0 46.4523401035052
LB233 n233 0 0.106382978723404
CV234 n234 0 48.4576411252319
LB234 n234 0 0.102040816326531
CV235 n235 0 50.4646762513524
LB235 n235 0 0.0980392156862745
CV236 n236 0 52.473342964644
LB236 n236 0 0.0943396226415094
CV237 n237 0 54.4835428189869
LB237 n237 0 0.0909090909090909
CV238 n238 0 56.4951817863936
LB238 n238 0 0.087719298245614
CV239 n239 0 58.5081704639402
LB239 n239 0 0.0847457627118644
CV240 n240 0 0.975424212565018
LB240 n240 0 5
CV241 n241 0 2.92650334691249
LB241 n241 0 1.66666666666667
CV242 n242 0 4.87826808353674
LB242 n242 0 1
CV243 n243 0 6.83115417949352
LB243 n243 0 0.714285714285714
CV244 n244 0 8.78556691157389
LB244 n244 0 0.555555555555556
CV245 n245 0 10.74187167306
LB245 n245 0 0.454545454545455
CV246 n246 0 12.7003869653242
LB246 n246 0 0.384615384615385
CV247 n247 0 14.6613799868033
LB247 n247 0 0.333333333333333
CV248 n248 0 16.6250647797133
LB248 n248 0 0.294117647058823
CV249 n249 0 18.591602693816
LB249 n249 0 0.263157894736842
CV250 n250 0 20.5611047858753
LB250 n250 0 0.238095238095238
CV251 n251 0 22.5336356986521
LB251 n251 0 0.217391304347826
CV252 n252 0 24.5092185484474
LB252 n252 0 0.2
CV253 n253 0 26.4878403821031
LB253 n253 0 0.185185185185185
CV254 n254 0 28.4694578269133
LB254 n254 0 0.172413793103448
CV255 n255 0 30.4540026346893
LB255 n255 0 0.161290322580645
CV256 n256 0 32.441386901742
LB256 n256 0 0.151515151515151
CV257 n257 0 34.4315078210375
LB257 n257 0 0.142857142857143
CV258 n258 0 36.4242518861762
LB258 n258 0 0.135135135135135
CV259 n259 0 38.4194985170614
LB259 n259 0 0.128205128205128
CV260 n260 0 40.417123114231
LB260 n260 0 0.121951219512195
CV261 n261 0 42.4169995741859
LB261 n261 0 0.116279069767442
CV262 n262 0 44.4190023136737
LB262 n262 0 0.111111111111111
CV263 n263 0 46.4230078589267
LB263 n263 0 0.106382978723404
CV264 n264 0 48.4288960583323
LB264 n264 0 0.102040816326531
CV265 n265 0 50.4365509756736
LB265 n265 0 0.0980392156862745
CV266 n266 0 52.4458615172957
LB266 n266 0 0.0943396226415094
CV267 n267 0 54.4567218414081
LB267 n267 0 0.0909090909090909
CV268 n268 0 56.469031591972
LB268 n268 0 0.087719298245614
CV269 n269 0 58.4826959937863
LB269 n269 0 0.0847457627118644
CV270 n270 0 0.973551239872241
LB270 n270 0 5
CV271 n271 0 2.92091726152114
LB271 n271 0 1.66666666666667
CV272 n272 0 4.86906573696457
LB272 n272 0 1
CV273 n273 0 6.81849166720773
LB273 n273 0 0.714285714285714
CV274 n274 0 8.7696521366009
LB274 n274 0 0.555555555555556
CV275 n275 0 10.7229549415349
LB275 n275 0 0.454545454545455
CV276 n276 0 12.6787504285808
LB276 n276 0 0.384615384615385
CV277 n277 0 14.6373267536658
LB277 n277 0 0.333333333333333
CV278 n278 0 16.5989084347265
LB278 n278 0 0.294117647058823
CV279 n279 0 18.5636578020096
LB279 n279 0 0.263157894736842
CV280 n280 0 20.5316787774293
LB280 n280 0 0.238095238095238
CV281 n281 0 22.503022339622
LB281 n281 0 0.217391304347826
CV282 n282 0 24.4776930402472
LB282 n282 0 0.2
CV283 n283 0 26.4556560061231
LB283 n283 0 0.185185185185185
CV284 n284 0 28.4368439654652
LB284 n284 0 0.172413793103448
CV285 n285 0 30.4211639524744
LB285 n285 0 0.161290322580645
CV286 n286 0 32.4085034562572
LB286 n286 0 0.151515151515151
CV287 n287 0 34.398735877308
LB287 n287 0 0.142857142857143
CV288 n288 0 36.3917252327682
LB288 n288 0 0.135135135135135
CV289 n289 0 38.3873301096261
LB289 n289 0 0.128205128205128
CV290 n290 0 40.385406904706
LB290 n290 0 0.121951219512195
CV291 n291 0 42.3858124147369
LB291 n291 0 0.116279069767442
CV292 n292 0 44.3884058524011
LB292 n292 0 0.111111111111111
CV293 n293 0 46.3930503682707
LB293 n293 0 0.106382978723404
CV294 n294 0 48.3996141567079
LB294 n294 0 0.102040816326531
CV295 n295 0 50.4079712183383
LB295 n295 0 0.0980392156862745
CV296 n296 0 52.4180018442442
LB296 n296 0 0.0943396226415094
CV297 n297 0 54.429592878758
LB297 n297 0 0.0909090909090909
CV298 n298 0 56.4426378094228
LB298 n298 0 0.087719298245614
CV299 n299 0 58.457036724835
LB299 n299 0 0.0847457627118644
CV300 n300 0 0.971501791806325
LB300 n300 0 5
CV301 n301 0 2.91480835961995
LB301 n301 0 1.66666666666667
CV302 n302 0 4.85901353230822
LB302 n302 0 1
CV303 n303 0 6.80468273179868
LB303 n303 0 0.714285714285714
CV304 n304 0 8.75233373832547
LB304 n304 0 0.555555555555556
CV305 n305 0 10.7024228725468
LB305 n305 0 0.454545454545455
CV306 n306 0 12.6553355293567
LB306 n306 0 0.384615384615385
CV307 n307 0 14.6113812575179
LB307 n307 0 0.333333333333333
CV308 n308 0 16.5707931008359
LB308 n308 0 0.294117647058823
CV309 n309 0 18.5337305601959
LB309 n309 0 0.263157894736842
CV310 n310 0 20.5002853308751
LB310 n310 0 0.238095238095238
CV311 n311 0 22.4704889100539
LB311 n311 0 0.217391304347826
CV312 n312 0 24.4443212251266
LB312 n312 0 0.2
CV313 n313 0 26.4217195635802
LB313 n313 0 0.185185185185185
CV314 n314 0 28.4025872503197
LB314 n314 0 0.172413793103448
CV315 n315 0 30.3868016869234
LB315 n315 0 0.161290322580645
CV316 n316 0 32.3742215186808
LB316 n316 0 0.151515151515151
CV317 n317 0 34.3646928186525
LB317 n317 0 0.142857142857143
CV318 n318 0 36.358054270417
LB318 n318 0 0.135135135135135
CV319 n319 0 38.3541413946012
LB319 n319 0 0.128205128205128
CV320 n320 0 40.3527899033538
LB320 n320 0 0.121951219512195
CV321 n321 0 42.3538382870905
LB321 n321 0 0.116279069767442
CV322 n322 0 44.3571297443963
LB322 n322 0 0.111111111111111
CV323 n323 0 46.3625135634261
LB323 n323 0 0.106382978723404
CV324 n324 0 48.3698460550596
LB324 n324 0 0.102040816326531
CV325 n325 0 50.3789911270665
LB325 n325 0 0.0980392156862745
CV326 n326 0 52.3898205764425
LB326 n326 0 0.0943396226415094
CV327 n327 0 54.4022141650735
LB327 n327 0 0.0909090909090909
CV328 n328 0 56.4160595326787
LB328 n328 0 0.087719298245614
CV329 n329 0 58.4312519909471
LB329 n329 0 0.0847457627118644
CV330 n330 0 0.969249364422904
LB330 n330 0 5
CV331 n331 0 2.90809889879279
LB331 n331 0 1.66666666666667
CV332 n332 0 4.84798758571206
LB332 n332 0 1
CV333 n333 0 6.78956517963613
LB333 n333 0 0.714285714285714
CV334 n334 0 8.7334209154172
LB334 n334 0 0.555555555555556
CV335 n335 0 10.6800666444145
LB335 n335 0 0.454545454545455
CV336 n336 0 12.6299259448472
LB336 n336 0 0.384615384615385
CV337 n337 0 14.5833293263885
LB337 n337 0 0.333333333333333
CV338 n338 0 16.5405149702386
LB338 n338 0 0.294117647058823
CV339 n339 0 18.5016339774765
LB339 n339 0 0.263157894736842
CV340 n340 0 20.4667588708409
LB340 n340 0 0.238095238095238
CV341 n341 0 22.4358940819056
LB341 n341 0 0.217391304347826
CV342 n342 0 24.4089872972786
LB342 n342 0 0.2
CV343 n343 0 26.3859407654299
LB343 n343 0 0.185185185185185
CV344 n344 0 28.3666219203072
LB344 n344 0 0.172413793103448
CV345 n345 0 30.3508729166657
LB345 n345 0 0.161290322580645
CV346 n346 0 32.3385188711917
LB346 n346 0 0.151515151515151
CV347 n347 0 34.3293747542746
LB347 n347 0 0.142857142857143
CV348 n348 0 36.3232509811538
LB348 n348 0 0.135135135135135
CV349 n349 0 38.3199578150879
LB349 n349 0 0.128205128205128
CV350 n350 0 40.3193087281788
LB350 n350 0 0.121951219512195
CV351 n351 0 42.3211228763859
LB351 n351 0 0.116279069767442
CV352 n352 0 44.3252268416458
LB352 n352 0 0.111111111111111
CV353 n353 0 46.3314557817863
LB353 n353 0 0.106382978723404
CV354 n354 0 48.339654112351
LB354 n354 0 0.102040816326531
CV355 n355 0 50.3496758264394
LB355 n355 0 0.0980392156862745
CV356 n356 0 52.3613845410274
LB356 n356 0 0.0943396226415094
CV357 n357 0 54.3746533420061
LB357 n357 0 0.0909090909090909
CV358 n358 0 56.3893644858648
LB358 n358 0 0.087719298245614
CV359 n359 0 58.4054090036976
LB359 n359 0 0.0847457627118644
CV360 n360 0 0.966761796077371
LB360 n360 0 5
CV361 n361 0 2.90069476991398
LB361 n361 0 1.66666666666667
CV362 n362 0 4.83583865399482
LB362 n362 0 1
CV363 n363 0 6.77294500940971
LB363 n363 0 0.714285714285714
CV364 n364 0 8.71268759040376
LB364 n364 0 0.555555555555556
CV365 n365 0 10.655641692658
LB365 n365 0 0.454545454545455
CV366 n366 0 12.6022718119737
LB366 n366 0 0.384615384615385
CV367 n367 0 14.5529275443249
LB367 n367 0 0.333333333333333
CV368 n368 0 16.5078466919882
LB368 n368 0 0.294117647058823
CV369 n369 0 18.4671639380219
LB369 n369 0 0.263157894736842
CV370 n370 0 20.4309232317307
LB370 n370 0 0.238095238095238
CV371 n371 0 22.3990921205621
LB371 n371 0 0.217391304347826
CV372 n372 0 24.3715765566372
LB372 n372 0 0.2
CV373 n373 0 26.3482350863383
LB373 n373 0 0.185185185185185
CV374 n374 0 28.3288917121031
LB374 n374 0 0.172413793103448
CV375 n375 0 30.3133470435555
LB375 n375 0 0.161290322580645
CV376 n376 0 32.3013876073095
LB376 n376 0 0.151515151515151
CV377 n377 0 34.2927933594474
LB377 n377 0 0.142857142857143
CV378 n378 0 36.2873435521243
LB378 n378 0 0.135135135135135
CV379 n379 0 38.2848211610819
LB379 n379 0 0.128205128205128
CV380 n380 0 40.2850160993316
LB380 n380 0 0.121951219512195
CV381 n381 0 42.2877274369825
LB381 n381 0 0.116279069767442
CV382 n382 0 44.2927648281999
LB382 n382 0 0.111111111111111
CV383 n383 0 46.2999493207469
LB383 n383 0 0.106382978723404
CV384 n384 0 48.3091136961737
LB384 n384 0 0.102040816326531
CV385 n385 0 50.3201024623223
LB385 n385 0 0.0980392156862745
CV386 n386 0 52.3327715959332
LB386 n386 0 0.0943396226415094
CV387 n387 0 54.3469881124413
LB387 n387 0 0.0909090909090909
CV388 n388 0 56.362629522647
LB388 n388 0 0.087719298245614
CV389 n389 0 58.3795832216708
LB389 n389 0 0.0847457627118644
CV390 n390 0 0.963999652871862
LB390 n390 0 5
CV391 n391 0 2.89248091289263
LB391 n391 0 1.66666666666667
CV392 n392 0 4.82238529870442
LB392 n392 0 1
CV393 n393 0 6.75458834039299
LB393 n393 0 0.714285714285714
CV394 n394 0 8.68986420543776
LB394 n394 0 0.555555555555556
CV395 n395 0 10.6288603638759
LB395 n395 0 0.454545454545455
CV396 n396 0 12.5720839747393
LB396 n396 0 0.384615384615385
CV397 n397 0 14.5198995083014
LB397 n397 0 0.333333333333333
CV398 n398 0 16.4725357443983
LB398 n398 0 0.294117647058823
CV399 n399 0 18.4300995447786
LB399 n399 0 0.263157894736842
CV400 n400 0 20.3925936617911
LB400 n400 0 0.238095238095238
CV401 n401 0 22.3599361549868
LB401 n401 0 0.217391304347826
CV402 n402 0 24.3319795361649
LB402 n402 0 0.2
CV403 n403 0 26.3085283732648
LB403 n403 0 0.185185185185185
CV404 n404 0 28.289354634574
LB404 n404 0 0.172413793103448
CV405 n405 0 30.2742104880632
LB405 n405 0 0.161290322580645
CV406 n406 0 32.2628385733004
LB406 n406 0 0.151515151515151
CV407 n407 0 34.254979949594
LB407 n407 0 0.142857142857143
CV408 n408 0 36.2503800195527
LB408 n408 0 0.135135135135135
CV409 n409 0 38.2487927593395
LB409 n409 0 0.128205128205128
CV410 n410 0 40.2499835788815
LB410 n410 0 0.121951219512195
CV411 n411 0 42.2537311049632
LB411 n411 0 0.116279069767442
CV412 n412 0 44.259828139754
LB412 n412 0 0.111111111111111
CV413 n413 0 46.2680820047279
LB413 n413 0 0.106382978723404
CV414 n414 0 48.2783144396327
LB414 n414 0 0.102040816326531
CV415 n415 0 50.2903611904032
LB415 n415 0 0.0980392156862745
CV416 n416 0 52.3040713895282
LB416 n416 0 0.0943396226415094
CV417 n417 0 54.3193068073418
LB417 n417 0 0.0909090909090909
CV418 n418 0 56.3359410325857
LB418 n418 0 0.087719298245614
CV419 n419 0 58.3538586247077
LB419 n419 0 0.0847457627118644
CV420 n420 0 0.960914020795729
LB420 n420 0 5
CV421 n421 0 2.88331508861242
LB421 n421 0 1.66666666666667
CV422 n422 0 4.80740472217132
LB422 n422 0 1
CV423 n423 0 6.7342108165031
LB423 n423 0 0.714285714285714
CV424 n424 0 8.66462727564599
LB424 n424 0 0.555555555555556
CV425 n425 0 10.5993829686172
LB425 n425 0 0.454545454545455
CV426 n426 0 12.5390274574135
LB426 n426 0 0.384615384615385
CV427 n427 0 14.4839321495531
LB427 n427 0 0.333333333333333
CV428 n428 0 16.4343035895364
LB428 n428 0 0.294117647058823
CV429 n429 0 18.3902047672533
LB429 n429 0 0.263157894736842
CV430 n430 0 20.3515804375141
LB430 n430 0 0.238095238095238
CV431 n431 0 22.3182831685554
LB431 n431 0 0.217391304347826
CV432 n432 0 24.2900978060804
LB432 n432 0 0.2
CV433 n433 0 26.2667629817379
LB433 n433 0 0.185185185185185
CV434 n434 0 28.2479890611779
LB434 n434 0 0.172413793103448
CV435 n435 0 30.233472469045
LB435 n435 0 0.161290322580645
CV436 n436 0 32.2229066623204
LB436 n436 0 0.151515151515151
CV437 n437 0 34.2159901940472
LB437 n437 0 0.142857142857143
CV438 n438 0 36.2124323667768
LB438 n438 0 0.135135135135135
CV439 n439 0 38.2119569624408
LB439 n439 0 0.128205128205128
CV440 n440 0 40.2143044852487
LB440 n440 0 0.121951219512195
CV441 n441 0 42.219233288526
LB441 n441 0 0.116279069767442
CV442 n442 0 44.2265198884778
LB442 n442 0 0.111111111111111
CV443 n443 0 46.2359587049693
LB443 n443 0 0.106382978723404
CV444 n444 0 48.2473614148535
LB444 n444 0 0.102040816326531
CV445 n445 0 50.2605560580536
LB445 n445 0 0.0980392156862745
CV446 n446 0 52.2753860001292
LB446 n446 0 0.0943396226415094
CV447 n447 0 54.2917088263924
LB447 n447 0 0.0909090909090909
CV448 n448 0 56.309395220565
LB448 n448 0 0.087719298245614
CV449 n449 0 58.3283278642553
LB449 n449 0 0.0847457627118644
CV450 n450 0 0.957443430629066
LB450 n450 0 5
CV451 n451 0 2.87301927181394
LB451 n451 0 1.66666666666667
CV452 n452 0 4.79062030381396
LB452 n452 0 1
CV453 n453 0 6.7114635549321
LB453 n453 0 0.714285714285714
CV454 n454 0 8.63658604378135
LB454 n454 0 0.555555555555556
CV455 n455 0 10.566806980733
LB455 n455 0 0.454545454545455
CV456 n456 0 12.5027143242884
LB456 n456 0 0.384615384615385
CV457 n457 0 14.4446726107383
LB457 n457 0 0.333333333333333
CV458 n458 0 16.3928463032174
LB458 n458 0 0.294117647058823
CV459 n459 0 18.3472321573759
LB459 n459 0 0.263157894736842
CV460 n460 0 20.3076948173024
LB460 n460 0 0.238095238095238
CV461 n461 0 22.2740013360658
LB461 n461 0 0.217391304347826
CV462 n462 0 24.245851944745
LB462 n462 0 0.2
CV463 n463 0 26.2229057893085
LB463 n463 0 0.185185185185185
CV464 n464 0 28.2048013630494
LB464 n464 0 0.172413793103448
CV465 n465 0 30.191171986009
LB465 n465 0 0.161290322580645
CV466 n466 0 32.18165699971
LB466 n466 0 0.151515151515151
CV467 n467 0 34.175909451466
LB467 n467 0 0.142857142857143
CV468 n468 0 36.1736010216013
LB468 n468 0 0.135135135135135
CV469 n469 0 38.1744248610617
LB469 n469 0 0.128205128205128
CV470 n470 0 40.1780968965207
LB470 n470 0 0.121951219512195
CV471 n471 0 42.1843560486735
LB471 n471 0 0.116279069767442
CV472 n472 0 44.1929637088793
LB472 n472 0 0.111111111111111
CV473 n473 0 46.2037027343558
LB473 n473 0 0.106382978723404
CV474 n474 0 48.2163761534222
LB474 n474 0 0.102040816326531
CV475 n475 0 50.230805718426
LB475 n475 0 0.0980392156862745
CV476 n476 0 52.2468304027995
LB476 n476 0 0.0943396226415094
CV477 n477 0 54.2643049078162
LB477 n477 0 0.0909090909090909
CV478 n478 0 56.2830982218886
LB478 n478 0 0.087719298245614
CV479 n479 0 58.3030922588018
LB479 n479 0 0.0847457627118644
CV480 n480 0 0.9535094854036
LB480 n480 0 5
CV481 n481 0 2.86136752694328
LB481 n481 0 1.66666666666667
CV482 n482 0 4.77168438012327
LB482 n482 0 1
CV483 n483 0 6.68591432394119
LB483 n483 0 0.714285714285714
CV484 n484 0 8.60526542018822
LB484 n484 0 0.555555555555556
CV485 n485 0 10.5306542244789
LB485 n485 0 0.454545454545455
CV486 n486 0 12.4626963806127
LB486 n486 0 0.384615384615385
CV487 n487 0 14.4017265690031
LB487 n487 0 0.333333333333333
CV488 n488 0 16.3478377822069
LB488 n488 0 0.294117647058823
CV489 n489 0 18.3009297467993
LB489 n489 0 0.263157894736842
CV490 n490 0 20.260758319516
LB490 n490 0 0.238095238095238
CV491 n491 0 22.2269804902867
LB491 n491 0 0.217391304347826
CV492 n492 0 24.1991922387586
LB492 n492 0 0.2
CV493 n493 0 26.1769584448117
LB493 n493 0 0.185185185185185
CV494 n494 0 28.1598352729224
LB494 n494 0 0.172413793103448
CV495 n495 0 30.1473860666065
LB495 n495 0 0.161290322580645
CV496 n496 0 32.1391919934643
LB496 n496 0 0.151515151515151
CV497 n497 0 34.1348586447093
LB497 n497 0 0.142857142857143
CV498 n498 0 36.1340196396259
LB498 n498 0 0.135135135135135
CV499 n499 0 38.1363380930414
LB499 n499 0 0.128205128205128
CV500 n500 0 40.1415066153487
LB500 n500 0 0.121951219512195
CV501 n501 0 42.149246349604
LB501 n501 0 0.116279069767442
CV502 n502 0 44.1593054150593
LB502 n502 0 0.111111111111111
CV503 n503 0 46.1714570205021
LB503 n503 0 0.106382978723404
CV504 n504 0 48.1854974302585
LB504 n504 0 0.102040816326531
CV505 n505 0 50.2012439060212
LB505 n505 0 0.0980392156862745
CV506 n506 0 52.2185327043248
LB506 n506 0 0.0943396226415094
CV507 n507 0 54.237217178615
LB507 n507 0 0.0909090909090909
CV508 n508 0 56.2571660132842
LB508 n508 0 0.087719298245614
CV509 n509 0 58.2782616022957
LB509 n509 0 0.0847457627118644
CV510 n510 0 0.949010495013647
LB510 n510 0 5
CV511 n511 0 2.84806855981932
LB511 n511 0 1.66666666666667
CV512 n512 0 4.75015404493148
LB512 n512 0 1
CV513 n513 0 6.65702209017161
LB513 n513 0 0.714285714285714
CV514 n514 0 8.5700842572692
LB514 n514 0 0.555555555555556
CV515 n515 0 10.4903561688689
LB515 n515 0 0.454545454545455
CV516 n516 0 12.4184587281525
LB516 n516 0 0.384615384615385
CV517 n517 0 14.3546595549142
LB517 n517 0 0.333333333333333
CV518 n518 0 16.2989372392995
LB518 n518 0 0.294117647058823
CV519 n519 0 18.2510527075287
LB519 n519 0 0.263157894736842
CV520 n520 0 20.2106166106385
LB520 n520 0 0.238095238095238
CV521 n521 0 22.1771466495304
LB521 n521 0 0.217391304347826
CV522 n522 0 24.1501127066292
LB522 n522 0 0.2
CV523 n523 0 26.1289701677477
LB523 n523 0 0.185185185185185
CV524 n524 0 28.1131830842296
LB524 n524 0 0.172413793103448
CV525 n525 0 30.1022392403317
LB525 n525 0 0.161290322580645
CV526 n526 0 32.095659122783
LB526 n526 0 0.151515151515151
CV527 n527 0 34.0930005017555
LB527 n527 0 0.142857142857143
CV528 n528 0 36.0938599830255
LB528 n528 0 0.135135135135135
CV529 n529 0 38.0978725605359
LB529 n529 0 0.128205128205128
CV530 n530 0 40.1047099197213
LB530 n530 0 0.121951219512195
CV531 n531 0 42.1140780218446
LB531 n531 0 0.116279069767442
CV532 n532 0 44.1257143332649
LB532 n532 0 0.111111111111111
CV533 n533 0 46.1393849417459
LB533 n533 0 0.106382978723404
CV534 n534 0 48.1548817148934
LB534 n534 0 0.102040816326531
CV535 n535 0 50.1720195949604
LB535 n535 0 0.0980392156862745
CV536 n536 0 52.1906340825907
LB536 n536 0 0.0943396226415094
CV537 n537 0 54.210578934182
LB537 n537 0 0.0909090909090909
CV538 n538 0 56.2317240793864
LB538 n538 0 0.087719298245614
CV539 n539 0 58.2539537538741
LB539 n539 0 0.0847457627118644
CV540 n540 0 0.943811956344319
LB540 n540 0 5
CV541 n541 0 2.8327399916739
LB541 n541 0 1.66666666666667
CV542 n542 0 4.72545651254794
LB542 n542 0 1
CV543 n543 0 6.62410232669201
LB543 n543 0 0.714285714285714
CV544 n544 0 8.53032801097994
LB544 n544 0 0.555555555555556
CV545 n545 0 10.4452381165545
LB545 n545 0 0.454545454545455
CV546 n546 0 12.3694162193477
LB546 n546 0 0.384615384615385
CV547 n547 0 14.3030038840728
LB547 n547 0 0.333333333333333
CV548 n548 0 16.2458035726856
LB548 n548 0 0.294117647058823
CV549 n549 0 18.1973819461033
LB549 n549 0 0.263157894736842
CV550 n550 0 20.1571595962748
LB550 n550 0 0.238095238095238
CV551 n551 0 22.1244816241374
LB551 n551 0 0.217391304347826
CV552 n552 0 24.0986689817776
LB552 n552 0 0.2
CV553 n553 0 26.0790532753137
LB553 n553 0 0.185185185185185
CV554 n554 0 28.0649986237623
LB554 n554 0 0.172413793103448
CV555 n555 0 30.0559140352054
LB555 n555 0 0.161290322580645
CV556 n556 0 32.0512591916695
LB556 n556 0 0.151515151515151
CV557 n557 0 34.0505458682623
LB557 n557 0 0.142857142857143
CV558 n558 0 36.0533366089141
LB558 n558 0 0.135135135135135
CV559 n559 0 38.0592417944415
LB559 n559 0 0.128205128205128
CV560 n560 0 40.0679158713407
LB560 n560 0 0.121951219512195
CV561 n561 0 42.079053244215
LB561 n561 0 0.116279069767442
CV562 n562 0 44.092384148711
LB562 n562 0 0.111111111111111
CV563 n563 0 46.1076706947115
LB563 n563 0 0.106382978723404
CV564 n564 0 48.1247031846301
LB564 n564 0 0.102040816326531
CV565 n565 0 50.14329675629
LB565 n565 0 0.0980392156862745
CV566 n566 0 52.1632883648038
LB566 n566 0 0.0943396226415094
CV567 n567 0 54.1845340965191
LB567 n567 0 0.0909090909090909
CV568 n568 0 56.2069067958553
LB568 n568 0 0.087719298245614
CV569 n569 0 58.2302939795633
LB569 n569 0 0.0847457627118644
CV570 n570 0 0.937731863834988
LB570 n570 0 5
CV571 n571 0 2.81486937068669
LB571 n571 0 1.66666666666667
CV572 n572 0 4.69683857017632
LB572 n572 0 1
CV573 n573 0 6.58627951337829
LB573 n573 0 0.714285714285714
CV574 n574 0 8.48511527190943
LB574 n574 0 0.555555555555556
CV575 n575 0 10.394504540034
LB575 n575 0 0.454545454545455
CV576 n576 0 12.3149167035312
LB576 n576 0 0.384615384615385
CV577 n577 0 14.2462754870976
LB577 n577 0 0.333333333333333
CV578 n578 0 16.1881203835689
LB578 n578 0 0.294117647058823
CV579 n579 0 18.1397524560681
LB579 n579 0 0.263157894736842
CV580 n580 0 20.1003495261332
LB580 n580 0 0.238095238095238
CV581 n581 0 22.0690486489105
LB581 n581 0 0.217391304347826
CV582 n582 0 24.0450003655555
LB582 n582 0 0.2
CV583 n583 0 26.0274013338771
LB583 n583 0 0.185185185185185
CV584 n584 0 28.0155116602617
LB584 n584 0 0.172413793103448
CV585 n585 0 30.0086620534284
LB585 n585 0 0.161290322580645
CV586 n586 0 32.0062545798
LB586 n586 0 0.151515151515151
CV587 n587 0 34.0077596482631
LB587 n587 0 0.142857142857143
CV588 n588 0 36.0127109722553
LB588 n588 0 0.135135135135135
CV589 n589 0 38.0206996285161
LB589 n589 0 0.128205128205128
CV590 n590 0 40.0313679015766
LB590 n590 0 0.121951219512195
CV591 n591 0 42.0444033175062
LB591 n591 0 0.116279069767442
CV592 n592 0 44.0595330857573
LB592 n592 0 0.111111111111111
CV593 n593 0 46.0765190515124
LB593 n593 0 0.106382978723404
CV594 n594 0 48.0951531897381
LB594 n594 0 0.102040816326531
CV595 n595 0 50.1152536303851
LB595 n595 0 0.0980392156862745
CV596 n596 0 52.1366611812591
LB596 n596 0 0.0943396226415094
CV597 n597 0 54.1592363039936
LB597 n597 0 0.0909090909090909
CV598 n598 0 56.1828564946995
LB598 n598 0 0.087719298245614
CV599 n599 0 58.2074140212664
LB599 n599 0 0.0847457627118644
CV600 n600 0 0.930517198298853
LB600 n600 0 5
CV601 n601 0 2.79375319722567
LB601 n601 0 1.66666666666667
CV602 n602 0 4.66329132051969
LB602 n602 0 1
CV603 n603 0 6.54242225889851
LB603 n603 0 0.714285714285714
CV604 n604 0 8.43335920574106
LB604 n604 0 0.555555555555556
CV605 n605 0 10.3372308752131
LB605 n605 0 0.454545454545455
CV606 n606 0 12.2542581747132
LB606 n606 0 0.384615384615385
CV607 n607 0 14.1840074014681
LB607 n607 0 0.333333333333333
CV608 n608 0 16.1256368642615
LB608 n608 0 0.294117647058823
CV609 n609 0 18.0780947994691
LB609 n609 0 0.263157894736842
CV610 n610 0 20.0402588612137
LB610 n610 0 0.238095238095238
CV611 n611 0 22.011024604383
LB611 n611 0 0.217391304347826
CV612 n612 0 23.9893558653423
LB612 n612 0 0.2
CV613 n613 0 25.9743093488381
LB613 n613 0 0.185185185185185
CV614 n614 0 27.9650429998142
LB614 n614 0 0.172413793103448
CV615 n615 0 29.9608148591734
LB615 n615 0 0.161290322580645
CV616 n616 0 31.960976784302
LB616 n616 0 0.151515151515151
CV617 n617 0 33.9649657615776
LB617 n617 0 0.142857142857143
CV618 n618 0 35.9722944353768
LB618 n618 0 0.135135135135135
CV619 n619 0 37.982541773411
LB619 n619 0 0.128205128205128
CV620 n620 0 39.9953443516766
LB620 n620 0 0.121951219512195
CV621 n621 0 42.0103884793196
LB621 n621 0 0.116279069767442
CV622 n622 0 44.0274032302578
LB622 n622 0 0.111111111111111
CV623 n623 0 46.0461543627817
LB623 n623 0 0.106382978723404
CV624 n624 0 48.0664390640342
LB624 n624 0 0.102040816326531
CV625 n625 0 50.0880814365706
LB625 n625 0 0.0980392156862745
CV626 n626 0 52.1109286387793
LB626 n626 0 0.0943396226415094
CV627 n627 0 54.1348475934234
LB627 n627 0 0.0909090909090909
CV628 n628 0 56.1597221850879
LB628 n628 0 0.087719298245614
CV629 n629 0 58.1854508755913
LB629 n629 0 0.0847457627118644
CV630 n630 0 0.921804624800045
LB630 n630 0 5
CV631 n631 0 2.76839806180029
LB631 n631 0 1.66666666666667
CV632 n632 0 4.62343595213312
LB632 n632 0 1
CV633 n633 0 6.49105618679175
LB633 n633 0 0.714285714285714
CV634 n634 0 8.37372927891669
LB634 n634 0 0.555555555555556
CV635 n635 0 10.2723732144046
LB635 n635 0 0.454545454545455
CV636 n636 0 12.1867322680544
LB636 n636 0 0.384615384615385
CV637 n637 0 14.1158100406554
LB637 n637 0 0.333333333333333
CV638 n638 0 16.058231172571
LB638 n638 0 0.294117647058823
CV639 n639 0 18.0124931182668
LB639 n639 0 0.263157894736842
CV640 n640 0 19.9771189682669
LB640 n640 0 0.238095238095238
CV641 n641 0 21.950738469946
LB641 n641 0 0.217391304347826
CV642 n642 0 23.932123147967
LB642 n642 0 0.2
CV643 n643 0 25.9201946747814
LB643 n643 0 0.185185185185185
CV644 n644 0 27.9140189660515
LB644 n644 0 0.172413793103448
CV645 n645 0 29.9127935205456
LB645 n645 0 0.161290322580645
CV646 n646 0 31.9158322839961
LB646 n646 0 0.151515151515151
CV647 n647 0 33.9225503400094
LB647 n647 0 0.142857142857143
CV648 n648 0 35.9324495768491
LB648 n648 0 0.135135135135135
CV649 n649 0 37.9451058268422
LB649 n649 0 0.128205128205128
CV650 n650 0 39.9601576193257
LB650 n650 0 0.121951219512195
CV651 n651 0 41.977296503213
LB651 n651 0 0.116279069767442
CV652 n652 0 43.9962588073834
LB652 n652 0 0.111111111111111
CV653 n653 0 46.0168186730643
LB653 n653 0 0.106382978723404
CV654 n654 0 48.0387821872719
LB654 n654 0 0.102040816326531
CV655 n655 0 50.0619824559336
LB655 n655 0 0.0980392156862745
CV656 n656 0 52.0862754714627
LB656 n656 0 0.0943396226415094
CV657 n657 0 54.1115366478321
LB657 n657 0 0.0909090909090909
CV658 n658 0 56.1376579142328
LB658 n658 0 0.087719298245614
CV659 n659 0 58.1645452750375
LB659 n659 0 0.0847457627118644
CV660 n660 0 0.91105125838875
LB660 n660 0 5
CV661 n661 0 2.73735356602757
LB661 n661 0 1.66666666666667
CV662 n662 0 4.57534763515195
LB662 n662 0 1
CV663 n663 0 6.43025275997867
LB663 n663 0 0.714285714285714
CV664 n664 0 8.30462954165229
LB664 n664 0 0.555555555555556
CV665 n665 0 10.1988191019818
LB665 n665 0 0.454545454545455
CV666 n666 0 12.1117147193383
LB666 n666 0 0.384615384615385
CV667 n667 0 14.0414720723069
LB667 n667 0 0.333333333333333
CV668 n668 0 15.9860033466713
LB668 n668 0 0.294117647058823
CV669 n669 0 17.9432618048995
LB669 n669 0 0.263157894736842
CV670 n670 0 19.9113788948593
LB670 n670 0 0.238095238095238
CV671 n671 0 21.8887139393526
LB671 n671 0 0.217391304347826
CV672 n672 0 23.8738579746358
LB672 n672 0 0.2
CV673 n673 0 25.865616345918
LB673 n673 0 0.185185185185185
CV674 n674 0 27.8629833058239
LB674 n674 0 0.172413793103448
CV675 n675 0 29.8651152342124
LB675 n675 0 0.161290322580645
CV676 n676 0 31.8713055140094
LB676 n676 0 0.151515151515151
CV677 n677 0 33.880962252924
LB677 n677 0 0.142857142857143
CV678 n678 0 35.8935891317568
LB678 n678 0 0.135135135135135
CV679 n679 0 37.9087692380275
LB679 n679 0 0.128205128205128
CV680 n680 0 39.9261515698029
LB680 n680 0 0.121951219512195
CV681 n681 0 41.94543984411
LB681 n681 0 0.116279069767442
CV682 n682 0 43.9663832525907
LB682 n682 0 0.111111111111111
CV683 n683 0 45.9887688408676
LB683 n683 0 0.106382978723404
CV684 n684 0 48.0124152305927
LB684 n684 0 0.102040816326531
CV685 n685 0 50.0371674460329
LB685 n685 0 0.0980392156862745
CV686 n686 0 52.0628926465181
LB686 n686 0 0.0943396226415094
CV687 n687 0 54.0894766006764
LB687 n687 0 0.0909090909090909
CV688 n688 0 56.1168207678429
LB688 n688 0 0.087719298245614
CV689 n689 0 58.1448398766541
LB689 n689 0 0.0847457627118644
CV690 n690 0 0.897404584100351
LB690 n690 0 5
CV691 n691 0 2.69841623101766
LB691 n691 0 1.66666666666667
CV692 n692 0 4.51628281266706
LB692 n692 0 1
CV693 n693 0 6.35750671201205
LB693 n693 0 0.714285714285714
CV694 n694 0 8.22423543794174
LB694 n694 0 0.555555555555556
CV695 n695 0 10.1155236411052
LB695 n695 0 0.454545454545455
CV696 n696 0 12.0288339565437
LB696 n696 0 0.384615384615385
CV697 n697 0 13.9611177455842
LB697 n697 0 0.333333333333333
CV698 n698 0 15.9094023293827
LB698 n698 0 0.294117647058823
CV699 n699 0 17.8710391297204
LB699 n699 0 0.263157894736842
CV700 n700 0 19.8437699417801
LB700 n700 0 0.238095238095238
CV701 n701 0 21.8257114471054
LB701 n701 0 0.217391304347826
CV702 n702 0 23.8153098685385
LB702 n702 0 0.2
CV703 n703 0 25.8112893958119
LB703 n703 0 0.185185185185185
CV704 n704 0 27.812603906976
LB704 n704 0 0.172413793103448
CV705 n705 0 29.8183951150409
LB705 n705 0 0.161290322580645
CV706 n706 0 31.827957580039
LB706 n706 0 0.151515151515151
CV707 n707 0 33.8407100024378
LB707 n707 0 0.142857142857143
CV708 n708 0 35.8561719037315
LB708 n708 0 0.135135135135135
CV709 n709 0 37.8739447817601
LB709 n709 0 0.128205128205128
CV710 n710 0 39.8936969189043
LB710 n710 0 0.121951219512195
CV711 n711 0 41.9151511430067
LB711 n711 0 0.116279069767442
CV712 n712 0 43.9380749617256
LB712 n712 0 0.111111111111111
CV713 n713 0 45.9622725989836
LB713 n713 0 0.106382978723404
CV714 n714 0 47.9875785538736
LB714 n714 0 0.102040816326531
CV715 n715 0 50.0138523781151
LB715 n715 0 0.0980392156862745
CV716 n716 0 52.0409744296598
LB716 n716 0 0.0943396226415094
CV717 n717 0 54.0688424094553
LB717 n717 0 0.0909090909090909
CV718 n718 0 56.0973685278105
LB718 n718 0 0.087719298245614
CV719 n719 0 58.1264771781356
LB719 n719 0 0.0847457627118644
CV720 n720 0 0.879437411803427
LB720 n720 0 5
CV721 n721 0 2.64807615975477
LB721 n721 0 1.66666666666667
CV722 n722 0 4.44226806469975
LB722 n722 0 1
CV723 n723 0 6.26966489261977
LB723 n723 0 0.714285714285714
CV724 n724 0 8.13068767651613
LB724 n724 0 0.555555555555556
CV725 n725 0 10.0218076040182
LB725 n725 0 0.454545454545455
CV726 n726 0 11.9382570944127
LB726 n726 0 0.384615384615385
CV727 n727 0 13.8754314193461
LB727 n727 0 0.333333333333333
CV728 n728 0 15.8293828376236
LB728 n728 0 0.294117647058823
CV729 n729 0 17.7968882285163
LB729 n729 0 0.263157894736842
CV730 n730 0 19.7753661360226
LB730 n730 0 0.238095238095238
CV731 n731 0 21.7627613514483
LB731 n731 0 0.217391304347826
CV732 n732 0 23.7574377843225
LB732 n732 0 0.2
CV733 n733 0 25.7580897189118
LB733 n733 0 0.185185185185185
CV734 n734 0 27.7636712627197
LB734 n734 0 0.172413793103448
CV735 n735 0 29.7733410891337
LB735 n735 0 0.161290322580645
CV736 n736 0 31.7864193538434
LB736 n736 0 0.151515151515151
CV737 n737 0 33.802354111535
LB737 n737 0 0.142857142857143
CV738 n738 0 35.8206950971564
LB738 n738 0 0.135135135135135
CV739 n739 0 37.8410732072858
LB739 n739 0 0.128205128205128
CV740 n740 0 39.8631843956239
LB740 n740 0 0.121951219512195
CV741 n741 0 41.886776991776
LB741 n741 0 0.116279069767442
CV742 n742 0 43.9116416802707
LB742 n742 0 0.111111111111111
CV743 n743 0 45.9376035518733
LB743 n743 0 0.106382978723404
CV744 n744 0 47.9645157736967
LB744 n744 0 0.102040816326531
CV745 n745 0 49.9922545277741
LB745 n745 0 0.0980392156862745
CV746 n746 0 52.0207149469218
LB746 n746 0 0.0943396226415094
CV747 n747 0 54.0498078375064
LB747 n747 0 0.0909090909090909
CV748 n748 0 56.0794570254493
LB748 n748 0 0.087719298245614
CV749 n749 0 58.1095971977604
LB749 n749 0 0.0847457627118644
CV750 n750 0 0.854547948063785
LB750 n750 0 5
CV751 n751 0 2.58042458229434
LB751 n751 0 1.66666666666667
CV752 n752 0 4.3475553058487
LB752 n752 0 1
CV753 n753 0 6.16312217848749
LB753 n753 0 0.714285714285714
CV754 n754 0 8.02265163942696
LB754 n754 0 0.555555555555556
CV755 n755 0 9.91792781013032
LB755 n755 0 0.454545454545455
CV756 n756 0 11.8411218871624
LB756 n756 0 0.384615384615385
CV757 n757 0 13.7859373946294
LB757 n757 0 0.333333333333333
CV758 n758 0 15.7475684476268
LB758 n758 0 0.294117647058823
CV759 n759 0 17.7223832178864
LB759 n759 0 0.263157894736842
CV760 n760 0 19.7076236433475
LB760 n760 0 0.238095238095238
CV761 n761 0 21.7011765356792
LB761 n761 0 0.217391304347826
CV762 n762 0 23.7014080755431
LB762 n762 0 0.2
CV763 n763 0 25.7070445787064
LB763 n763 0 0.185185185185185
CV764 n764 0 27.7170856441895
LB764 n764 0 0.172413793103448
CV765 n765 0 29.7307400459387
LB765 n765 0 0.161290322580645
CV766 n766 0 31.7473778615141
LB766 n766 0 0.151515151515151
CV767 n767 0 33.7664943898863
LB767 n767 0 0.142857142857143
CV768 n768 0 35.7876827473661
LB768 n768 0 0.135135135135135
CV769 n769 0 37.8106129186625
LB769 n769 0 0.128205128205128
CV770 n770 0 39.8350156480115
LB770 n770 0 0.121951219512195
CV771 n771 0 41.8606699828924
LB771 n771 0 0.116279069767442
CV772 n772 0 43.8873935896605
LB772 n772 0 0.111111111111111
CV773 n773 0 45.9150351836893
LB773 n773 0 0.106382978723404
CV774 n774 0 47.9434685806262
LB774 n774 0 0.102040816326531
CV775 n775 0 49.9725879966806
LB775 n775 0 0.0980392156862745
CV776 n776 0 52.0023043160571
LB776 n776 0 0.0943396226415094
CV777 n777 0 54.032542111011
LB777 n777 0 0.0909090909090909
CV778 n778 0 56.0632372505199
LB778 n778 0 0.087719298245614
CV779 n779 0 58.0943349716086
LB779 n779 0 0.0847457627118644
CV780 n780 0 0.817394929072615
LB780 n780 0 5
CV781 n781 0 2.48491028929597
LB781 n781 0 1.66666666666667
CV782 n782 0 4.22428701859633
LB782 n782 0 1
CV783 n783 0 6.03491156438892
LB783 n783 0 0.714285714285714
CV784 n784 0 7.9006048275572
LB784 n784 0 0.555555555555556
CV785 n785 0 9.80600861398597
LB785 n785 0 0.454545454545455
CV786 n786 0 11.7400767869052
LB786 n786 0 0.384615384615385
CV787 n787 0 13.6952698318388
LB787 n787 0 0.333333333333333
CV788 n788 0 15.6663663437825
LB788 n788 0 0.294117647058823
CV789 n789 0 17.6496434076243
LB789 n789 0 0.263157894736842
CV790 n790 0 19.6423762837313
LB790 n790 0 0.238095238095238
CV791 n791 0 21.6425310451169
LB791 n791 0 0.217391304347826
CV792 n792 0 23.6485671597512
LB792 n792 0 0.2
CV793 n793 0 25.6593045578021
LB793 n793 0 0.185185185185185
CV794 n794 0 27.6738307319095
LB794 n794 0 0.172413793103448
CV795 n795 0 29.6914341143642
LB795 n795 0 0.161290322580645
CV796 n796 0 31.711555458097
LB796 n796 0 0.151515151515151
CV797 n797 0 33.7337519198819
LB797 n797 0 0.142857142857143
CV798 n798 0 35.7576702790112
LB798 n798 0 0.135135135135135
CV799 n799 0 37.7830268114921
LB799 n799 0 0.128205128205128
CV800 n800 0 39.8095920586352
LB800 n800 0 0.121951219512195
CV801 n801 0 41.8371792221356
LB801 n801 0 0.116279069767442
CV802 n802 0 43.8656352641411
LB802 n802 0 0.111111111111111
CV803 n803 0 45.8948340376533
LB803 n803 0 0.106382978723404
CV804 n804 0 47.9246709502296
LB804 n804 0 0.102040816326531
CV805 n805 0 49.9550587926762
LB805 n805 0 0.0980392156862745
CV806 n806 0 51.9859244582519
LB806 n806 0 0.0943396226415094
CV807 n807 0 54.0172063466702
LB807 n807 0 0.0909090909090909
CV808 n808 0 56.0488522978497
LB808 n808 0 0.087719298245614
CV809 n809 0 58.0808179378782
LB809 n809 0 0.0847457627118644
CV810 n810 0 0.754903161599437
LB810 n810 0 5
CV811 n811 0 2.34200303121848
LB811 n811 0 1.66666666666667
CV812 n812 0 4.06435698910359
LB812 n812 0 1
CV813 n813 0 5.88614921429191
LB813 n813 0 0.714285714285714
CV814 n814 0 7.76919173380349
LB814 n814 0 0.555555555555556
CV815 n815 0 9.69119123878523
LB815 n815 0 0.454545454545455
CV816 n816 0 11.6397218497772
LB816 n816 0 0.384615384615385
CV817 n817 0 13.6072845296839
LB817 n817 0 0.333333333333333
CV818 n818 0 15.5889478665074
LB818 n818 0 0.294117647058823
CV819 n819 0 17.5812705351704
LB819 n819 0 0.263157894736842
CV820 n820 0 19.5817647665972
LB820 n820 0 0.238095238095238
CV821 n821 0 21.5885941062507
LB821 n821 0 0.217391304347826
CV822 n822 0 23.6003840801314
LB822 n822 0 0.2
CV823 n823 0 25.6160950149517
LB823 n823 0 0.185185185185185
CV824 n824 0 27.6349331516802
LB824 n824 0 0.172413793103448
CV825 n825 0 29.6562871529751
LB825 n825 0 0.161290322580645
CV826 n826 0 31.6796821579387
LB826 n826 0 0.151515151515151
CV827 n827 0 33.7047462304696
LB827 n827 0 0.142857142857143
CV828 n828 0 35.7311856700379
LB828 n828 0 0.135135135135135
CV829 n829 0 37.7587667123055
LB829 n829 0 0.128205128205128
CV830 n830 0 39.7873018680464
LB830 n830 0 0.121951219512195
CV831 n831 0 41.816639650493
LB831 n831 0 0.116279069767442
CV832 n832 0 43.8466567940387
LB832 n832 0 0.111111111111111
CV833 n833 0 45.8772523168878
LB833 n833 0 0.106382978723404
CV834 n834 0 47.9083429577697
LB834 n834 0 0.102040816326531
CV835 n835 0 49.9398596436399
LB835 n835 0 0.0980392156862745
CV836 n836 0 51.9717447363155
LB836 n836 0 0.0943396226415094
CV837 n837 0 54.0039498716713
LB837 n837 0 0.0909090909090909
CV838 n838 0 56.0364342526877
LB838 n838 0 0.087719298245614
CV839 n839 0 58.0691632924318
LB839 n839 0 0.0847457627118644
CV840 n840 0 0.62461404235982
LB840 n840 0 5
CV841 n841 0 2.12064863389888
LB841 n841 0 1.66666666666667
CV842 n842 0 3.87121953128556
LB842 n842 0 1
CV843 n843 0 5.72952329777669
LB843 n843 0 0.714285714285714
CV844 n844 0 7.63995148847173
LB844 n844 0 0.555555555555556
CV845 n845 0 9.58221531717144
LB845 n845 0 0.454545454545455
CV846 n846 0 11.546500017517
LB846 n846 0 0.384615384615385
CV847 n847 0 13.5268048504402
LB847 n847 0 0.333333333333333
CV848 n848 0 15.5190098316486
LB848 n848 0 0.294117647058823
CV849 n849 0 17.5201576113876
LB849 n849 0 0.263157894736842
CV850 n850 0 19.5280898121403
LB850 n850 0 0.238095238095238
CV851 n851 0 21.5412178171057
LB851 n851 0 0.217391304347826
CV852 n852 0 23.5583640418134
LB852 n852 0 0.2
CV853 n853 0 25.578648891625
LB853 n853 0 0.185185185185185
CV854 n854 0 27.601409792239
LB854 n854 0 0.172413793103448
CV855 n855 0 29.6261431297194
LB855 n855 0 0.161290322580645
CV856 n856 0 31.6524625403413
LB856 n856 0 0.151515151515151
CV857 n857 0 33.6800688330973
LB857 n857 0 0.142857142857143
CV858 n858 0 35.7087281809058
LB858 n858 0 0.135135135135135
CV859 n859 0 37.7382561996423
LB859 n859 0 0.128205128205128
CV860 n860 0 39.7685062364263
LB860 n860 0 0.121951219512195
CV861 n861 0 41.7993606841052
LB861 n861 0 0.116279069767442
CV862 n862 0 43.830724486065
LB862 n862 0 0.111111111111111
CV863 n863 0 45.8625202381678
LB863 n863 0 0.106382978723404
CV864 n864 0 47.8946844643814
LB864 n864 0 0.102040816326531
CV865 n865 0 49.9271647618291
LB865 n865 0 0.0980392156862745
CV866 n866 0 51.9599175950223
LB866 n866 0 0.0943396226415094
CV867 n867 0 53.9929065786694
LB867 n867 0 0.0909090909090909
CV868 n868 0 56.0261011310411
LB868 n868 0 0.087719298245614
CV869 n869 0 58.0594754104999
LB869 n869 0 0.0847457627118644
CV870 n870 0 0.219895780032328
LB870 n870 0 5
CV871 n871 0 1.84081421794156
LB871 n871 0 1.66666666666667
CV872 n872 0 3.69330791631487
LB872 n872 0 1
CV873 n873 0 5.59594316497544
LB873 n873 0 0.714285714285714
CV874 n874 0 7.53072324042168
LB874 n874 0 0.555555555555556
CV875 n875 0 9.4899213922211
LB875 n875 0 0.454545454545455
CV876 n876 0 11.4675572235274
LB876 n876 0 0.384615384615385
CV877 n877 0 13.4588844552086
LB877 n877 0 0.333333333333333
CV878 n878 0 15.4603066931166
LB878 n878 0 0.294117647058823
CV879 n879 0 17.4691837231529
LB879 n879 0 0.263157894736842
CV880 n880 0 19.4836047794847
LB880 n880 0 0.238095238095238
CV881 n881 0 21.5021906870214
LB881 n881 0 0.217391304347826
CV882 n882 0 23.5239416903903
LB882 n882 0 0.2
CV883 n883 0 25.5481271025214
LB883 n883 0 0.185185185185185
CV884 n884 0 27.5742073849091
LB884 n884 0 0.172413793103448
CV885 n885 0 29.6017796652823
LB885 n885 0 0.161290322580645
CV886 n886 0 31.6305396624301
LB886 n886 0 0.151515151515151
CV887 n887 0 33.6602549507869
LB887 n887 0 0.142857142857143
CV888 n888 0 35.6907460425197
LB888 n888 0 0.135135135135135
CV889 n889 0 37.7218728762985
LB889 n889 0 0.128205128205128
CV890 n890 0 39.7535250698395
LB890 n890 0 0.121951219512195
CV891 n891 0 41.7856148145656
LB891 n891 0 0.116279069767442
CV892 n892 0 43.8180716424344
LB892 n892 0 0.111111111111111
CV893 n893 0 45.8508385324321
LB893 n893 0 0.106382978723404
CV894 n894 0 47.8838689852513
LB894 n894 0 0.102040816326531
CV895 n895 0 49.9171248045921
LB895 n895 0 0.0980392156862745
CV896 n896 0 51.9505743991637
LB896 n896 0 0.0943396226415094
CV897 n897 0 53.9841914719725
LB897 n897 0 0.0909090909090909
CV898 n898 0 56.0179540002564
LB898 n898 0 0.087719298245614
CV899 n899 0 58.0518434354241
LB899 n899 0 0.0847457627118644
CV900 n900 0 0.200000000000003
LB900 n900 0 5
CV901 n901 0 1.78770385771683
LB901 n901 0 1.66666666666667
CV902 n902 0 3.62146792943742
LB902 n902 0 1
CV903 n903 0 5.51887804365368
LB903 n903 0 0.714285714285714
CV904 n904 0 7.45685424949239
LB904 n904 0 0.555555555555556
CV905 n905 0 9.42307087420432
LB905 n905 0 0.454545454545455
CV906 n906 0 11.4087513172528
LB906 n906 0 0.384615384615385
CV907 n907 0 13.4077965253518
LB907 n907 0 0.333333333333333
CV908 n908 0 15.4160889339217
LB908 n908 0 0.294117647058823
CV909 n909 0 17.4308721697405
LB909 n909 0 0.263157894736842
CV910 n910 0 19.4502912847468
LB910 n910 0 0.238095238095238
CV911 n911 0 21.4730821289513
LB911 n911 0 0.217391304347826
CV912 n912 0 23.4983693109444
LB912 n912 0 0.2
CV913 n913 0 25.5255361642404
LB913 n913 0 0.185185185185185
CV914 n914 0 27.5541407744156
LB914 n914 0 0.172413793103448
CV915 n915 0 29.5838611840099
LB915 n915 0 0.161290322580645
CV916 n916 0 31.6144591392429
LB916 n916 0 0.151515151515151
CV917 n917 0 33.6457557350913
LB917 n917 0 0.142857142857143
CV918 n918 0 35.6776147956368
LB918 n918 0 0.135135135135135
CV919 n919 0 37.7099313565903
LB919 n919 0 0.128205128205128
CV920 n920 0 39.7426235639023
LB920 n920 0 0.121951219512195
CV921 n921 0 41.7756268937903
LB921 n921 0 0.116279069767442
CV922 n922 0 43.8088899732403
LB922 n922 0 0.111111111111111
CV923 n923 0 45.8423715193364
LB923 n923 0 0.106382978723404
CV924 n924 0 47.8760380711129
LB924 n924 0 0.102040816326531
CV925 n925 0 49.9098622898565
LB925 n925 0 0.0980392156862745
CV926 n926 0 51.9438216719897
LB926 n926 0 0.0943396226415094
CV927 n927 0 53.9778975647657
LB927 n927 0 0.0909090909090909
CV928 n928 0 56.0120744065604
LB928 n928 0 0.087719298245614
CV929 n929 0 58.0463391354113
LB929 n929 0 0.0847457627118644
CV930 n930 0 0.559889185007248
LB930 n930 0 5
CV931 n931 0 1.95158884201847
LB931 n931 0 1.66666666666667
CV932 n932 0 3.64896041687534
LB932 n932 0 1
CV933 n933 0 5.49651633962516
LB933 n933 0 0.714285714285714
CV934 n934 0 7.41980924992572
LB934 n934 0 0.555555555555556
CV935 n935 0 9.38449607090551
LB935 n935 0 0.454545454545455
CV936 n936 0 11.3731356987813
LB936 n936 0 0.384615384615385
CV937 n937 0 13.3763107932347
LB937 n937 0 0.333333333333333
CV938 n938 0 15.3886895661511
LB938 n938 0 0.294117647058823
CV939 n939 0 17.4071217558203
LB939 n939 0 0.263157894736842
CV940 n940 0 19.4296716607776
LB940 n940 0 0.238095238095238
CV941 n941 0 21.455106775397
LB941 n941 0 0.217391304347826
CV942 n942 0 23.4826168233338
LB942 n942 0 0.2
CV943 n943 0 25.5116536632183
LB943 n943 0 0.185185185185185
CV944 n944 0 27.5418369081806
LB944 n944 0 0.172413793103448
CV945 n945 0 29.5728965094802
LB945 n945 0 0.161290322580645
CV946 n946 0 31.6046368080559
LB946 n946 0 0.151515151515151
CV947 n947 0 33.6369134294162
LB947 n947 0 0.142857142857143
CV948 n948 0 35.6696180748599
LB948 n948 0 0.135135135135135
CV949 n949 0 37.702668290699
LB949 n949 0 0.128205128205128
CV950 n950 0 39.7360004486152
LB950 n950 0 0.121951219512195
CV951 n951 0 41.7695648414733
LB951 n951 0 0.116279069767442
CV952 n952 0 43.8033221999513
LB952 n952 0 0.111111111111111
CV953 n953 0 45.8372411805401
LB953 n953 0 0.106382978723404
CV954 n954 0 47.871296528582
LB954 n954 0 0.102040816326531
CV955 n955 0 49.9054677175518
LB955 n955 0 0.0980392156862745
CV956 n956 0 51.9397379290503
LB956 n956 0 0.0943396226415094
CV957 n957 0 53.9740932797222
LB957 n957 0 0.0909090909090909
CV958 n958 0 56.0085222292904
LB958 n958 0 0.087719298245614
CV959 n959 0 58.0430151229336
LB959 n959 0 0.0847457627118644
CV960 n960 0 0.625306036985027
LB960 n960 0 5
CV961 n961 0 2.02362341092913
LB961 n961 0 1.66666666666667
CV962 n962 0 3.67347797393388
LB962 n962 0 1
CV963 n963 0 5.4953012084163
LB963 n963 0 0.714285714285714
CV964 n964 0 7.40953021310948
LB964 n964 0 0.555555555555556
CV965 n965 0 9.37218842495014
LB965 n965 0 0.454545454545455
CV966 n966 0 11.361306781992
LB966 n966 0 0.384615384615385
CV967 n967 0 13.3657080128199
LB967 n967 0 0.333333333333333
CV968 n968 0 15.3794202203012
LB968 n968 0 0.294117647058823
CV969 n969 0 17.3990787634412
LB969 n969 0 0.263157894736842
CV970 n970 0 19.4226920231186
LB970 n970 0 0.238095238095238
CV971 n971 0 21.4490283391665
LB971 n971 0 0.217391304347826
CV972 n972 0 23.477296330153
LB972 n972 0 0.2
CV973 n973 0 25.5069702860888
LB973 n973 0 0.185185185185185
CV974 n974 0 27.5376906790918
LB974 n974 0 0.172413793103448
CV975 n975 0 29.569205283678
LB975 n975 0 0.161290322580645
CV976 n976 0 31.6013331311765
LB976 n976 0 0.151515151515151
CV977 n977 0 33.6339417668265
LB977 n977 0 0.142857142857143
CV978 n978 0 35.666932507851
LB978 n978 0 0.135135135135135
CV979 n979 0 37.7002306538227
LB979 n979 0 0.128205128205128
CV980 n980 0 39.7337788426162
LB980 n980 0 0.121951219512195
CV981 n981 0 41.7675324516375
LB981 n981 0 0.116279069767442
CV982 n982 0 43.8014563574155
LB982 n982 0 0.111111111111111
CV983 n983 0 45.8355226149274
LB983 n983 0 0.106382978723404
CV984 n984 0 47.8697087707458
LB984 n984 0 0.102040816326531
CV985 n985 0 49.9039966200912
LB985 n985 0 0.0980392156862745
CV986 n986 0 51.9383712794258
LB986 n986 0 0.0943396226415094
CV987 n987 0 53.9728204864413
LB987 n987 0 0.0909090909090909
CV988 n988 0 56.0073340660011
LB988 n988 0 0.087719298245614
CV989 n989 0 58.0419035186285
LB989 n989 0 0.0847457627118644
CV990 n990 0 0.559889185007248
LB990 n990 0 5
CV991 n991 0 1.95158884201847
LB991 n991 0 1.66666666666667
CV992 n992 0 3.64896041687534
LB992 n992 0 1
CV993 n993 0 5.49651633962516
LB993 n993 0 0.714285714285714
CV994 n994 0 7.41980924992572
LB994 n994 0 0.555555555555556
CV995 n995 0 9.38449607090551
LB995 n995 0 0.454545454545455
CV996 n996 0 11.3731356987813
LB996 n996 0 0.384615384615385
CV997 n997 0 13.3763107932347
LB997 n997 0 0.333333333333333
CV998 n998 0 15.3886895661511
LB998 n998 0 0.294117647058823
CV999 n999 0 17.4071217558203
LB999 n999 0 0.263157894736842
CV1000 n1000 0 19.4296716607776
LB1000 n1000 0 0.238095238095238
CV1001 n1001 0 21.455106775397
LB1001 n1001 0 0.217391304347826
CV1002 n1002 0 23.4826168233338
LB1002 n1002 0 0.2
CV1003 n1003 0 25.5116536632183
LB1003 n1003 0 0.185185185185185
CV1004 n1004 0 27.5418369081806
LB1004 n1004 0 0.172413793103448
CV1005 n1005 0 29.5728965094802
LB1005 n1005 0 0.161290322580645
CV1006 n1006 0 31.6046368080559
LB1006 n1006 0 0.151515151515151
CV1007 n1007 0 33.6369134294162
LB1007 n1007 0 0.142857142857143
CV1008 n1008 0 35.6696180748599
LB1008 n1008 0 0.135135135135135
CV1009 n1009 0 37.702668290699
LB1009 n1009 0 0.128205128205128
CV1010 n1010 0 39.7360004486152
LB1010 n1010 0 0.121951219512195
CV1011 n1011 0 41.7695648414733
LB1011 n1011 0 0.116279069767442
CV1012 n1012 0 43.8033221999513
LB1012 n1012 0 0.111111111111111
CV1013 n1013 0 45.8372411805401
LB1013 n1013 0 0.106382978723404
CV1014 n1014 0 47.871296528582
LB1014 n1014 0 0.102040816326531
CV1015 n1015 0 49.9054677175518
LB1015 n1015 0 0.0980392156862745
CV1016 n1016 0 51.9397379290503
LB1016 n1016 0 0.0943396226415094
CV1017 n1017 0 53.9740932797222
LB1017 n1017 0 0.0909090909090909
CV1018 n1018 0 56.0085222292904
LB1018 n1018 0 0.087719298245614
CV1019 n1019 0 58.0430151229336
LB1019 n1019 0 0.0847457627118644
CV1020 n1020 0 0.2
LB1020 n1020 0 5
CV1021 n1021 0 1.78770385771683
LB1021 n1021 0 1.66666666666667
CV1022 n1022 0 3.62146792943742
LB1022 n1022 0 1
CV1023 n1023 0 5.51887804365368
LB1023 n1023 0 0.714285714285714
CV1024 n1024 0 7.45685424949239
LB1024 n1024 0 0.555555555555556
CV1025 n1025 0 9.42307087420432
LB1025 n1025 0 0.454545454545455
CV1026 n1026 0 11.4087513172528
LB1026 n1026 0 0.384615384615385
CV1027 n1027 0 13.4077965253518
LB1027 n1027 0 0.333333333333333
CV1028 n1028 0 15.4160889339217
LB1028 n1028 0 0.294117647058823
CV1029 n1029 0 17.4308721697405
LB1029 n1029 0 0.263157894736842
CV1030 n1030 0 19.4502912847468
LB1030 n1030 0 0.238095238095238
CV1031 n1031 0 21.4730821289513
LB1031 n1031 0 0.217391304347826
CV1032 n1032 0 23.4983693109444
LB1032 n1032 0 0.2
CV1033 n1033 0 25.5255361642404
LB1033 n1033 0 0.185185185185185
CV1034 n1034 0 27.5541407744156
LB1034 n1034 0 0.172413793103448
CV1035 n1035 0 29.5838611840099
LB1035 n1035 0 0.161290322580645
CV1036 n1036 0 31.6144591392429
LB1036 n1036 0 0.151515151515151
CV1037 n1037 0 33.6457557350913
LB1037 n1037 0 0.142857142857143
CV1038 n1038 0 35.6776147956368
LB1038 n1038 0 0.135135135135135
CV1039 n1039 0 37.7099313565903
LB1039 n1039 0 0.128205128205128
CV1040 n1040 0 39.7426235639023
LB1040 n1040 0 0.121951219512195
CV1041 n1041 0 41.7756268937903
LB1041 n1041 0 0.116279069767442
CV1042 n1042 0 43.8088899732403
LB1042 n1042 0 0.111111111111111
CV1043 n1043 0 45.8423715193364
LB1043 n1043 0 0.106382978723404
CV1044 n1044 0 47.8760380711129
LB1044 n1044 0 0.102040816326531
CV1045 n1045 0 49.9098622898565
LB1045 n1045 0 0.0980392156862745
CV1046 n1046 0 51.9438216719897
LB1046 n1046 0 0.0943396226415094
CV1047 n1047 0 53.9778975647657
LB1047 n1047 0 0.0909090909090909
CV1048 n1048 0 56.0120744065604
LB1048 n1048 0 0.087719298245614
CV1049 n1049 0 58.0463391354113
LB1049 n1049 0 0.0847457627118644
CV1050 n1050 0 0.219895780032331
LB1050 n1050 0 5
CV1051 n1051 0 1.84081421794156
LB1051 n1051 0 1.66666666666667
CV1052 n1052 0 3.69330791631487
LB1052 n1052 0 1
CV1053 n1053 0 5.59594316497544
LB1053 n1053 0 0.714285714285714
CV1054 n1054 0 7.53072324042168
LB1054 n1054 0 0.555555555555556
CV1055 n1055 0 9.4899213922211
LB1055 n1055 0 0.454545454545455
CV1056 n1056 0 11.4675572235274
LB1056 n1056 0 0.384615384615385
CV1057 n1057 0 13.4588844552086
LB1057 n1057 0 0.333333333333333
CV1058 n1058 0 15.4603066931166
LB1058 n1058 0 0.294117647058823
CV1059 n1059 0 17.4691837231529
LB1059 n1059 0 0.263157894736842
CV1060 n1060 0 19.4836047794847
LB1060 n1060 0 0.238095238095238
CV1061 n1061 0 21.5021906870214
LB1061 n1061 0 0.217391304347826
CV1062 n1062 0 23.5239416903903
LB1062 n1062 0 0.2
CV1063 n1063 0 25.5481271025214
LB1063 n1063 0 0.185185185185185
CV1064 n1064 0 27.5742073849091
LB1064 n1064 0 0.172413793103448
CV1065 n1065 0 29.6017796652823
LB1065 n1065 0 0.161290322580645
CV1066 n1066 0 31.6305396624302
LB1066 n1066 0 0.151515151515151
CV1067 n1067 0 33.6602549507869
LB1067 n1067 0 0.142857142857143
CV1068 n1068 0 35.6907460425197
LB1068 n1068 0 0.135135135135135
CV1069 n1069 0 37.7218728762985
LB1069 n1069 0 0.128205128205128
CV1070 n1070 0 39.7535250698395
LB1070 n1070 0 0.121951219512195
CV1071 n1071 0 41.7856148145656
LB1071 n1071 0 0.116279069767442
CV1072 n1072 0 43.8180716424344
LB1072 n1072 0 0.111111111111111
CV1073 n1073 0 45.8508385324321
LB1073 n1073 0 0.106382978723404
CV1074 n1074 0 47.8838689852513
LB1074 n1074 0 0.102040816326531
CV1075 n1075 0 49.9171248045921
LB1075 n1075 0 0.0980392156862745
CV1076 n1076 0 51.9505743991637
LB1076 n1076 0 0.0943396226415094
CV1077 n1077 0 53.9841914719725
LB1077 n1077 0 0.0909090909090909
CV1078 n1078 0 56.0179540002564
LB1078 n1078 0 0.087719298245614
CV1079 n1079 0 58.0518434354241
LB1079 n1079 0 0.0847457627118644
CV1080 n1080 0 0.624614042359821
LB1080 n1080 0 5
CV1081 n1081 0 2.12064863389888
LB1081 n1081 0 1.66666666666667
CV1082 n1082 0 3.87121953128556
LB1082 n1082 0 1
CV1083 n1083 0 5.72952329777669
LB1083 n1083 0 0.714285714285714
CV1084 n1084 0 7.63995148847174
LB1084 n1084 0 0.555555555555556
CV1085 n1085 0 9.58221531717144
LB1085 n1085 0 0.454545454545455
CV1086 n1086 0 11.546500017517
LB1086 n1086 0 0.384615384615385
CV1087 n1087 0 13.5268048504402
LB1087 n1087 0 0.333333333333333
CV1088 n1088 0 15.5190098316486
LB1088 n1088 0 0.294117647058823
CV1089 n1089 0 17.5201576113876
LB1089 n1089 0 0.263157894736842
CV1090 n1090 0 19.5280898121403
LB1090 n1090 0 0.238095238095238
CV1091 n1091 0 21.5412178171057
LB1091 n1091 0 0.217391304347826
CV1092 n1092 0 23.5583640418134
LB1092 n1092 0 0.2
CV1093 n1093 0 25.578648891625
LB1093 n1093 0 0.185185185185185
CV1094 n1094 0 27.601409792239
LB1094 n1094 0 0.172413793103448
CV1095 n1095 0 29.6261431297194
LB1095 n1095 0 0.161290322580645
CV1096 n1096 0 31.6524625403413
LB1096 n1096 0 0.151515151515151
CV1097 n1097 0 33.6800688330973
LB1097 n1097 0 0.142857142857143
CV1098 n1098 0 35.7087281809058
LB1098 n1098 0 0.135135135135135
CV1099 n1099 0 37.7382561996423
LB1099 n1099 0 0.128205128205128
CV1100 n1100 0 39.7685062364263
LB1100 n1100 0 0.121951219512195
CV1101 n1101 0 41.7993606841052
LB1101 n1101 0 0.116279069767442
CV1102 n1102 0 43.830724486065
LB1102 n1102 0 0.111111111111111
CV1103 n1103 0 45.8625202381678
LB1103 n1103 0 0.106382978723404
CV1104 n1104 0 47.8946844643814
LB1104 n1104 0 0.102040816326531
CV1105 n1105 0 49.9271647618291
LB1105 n1105 0 0.0980392156862745
CV1106 n1106 0 51.9599175950223
LB1106 n1106 0 0.0943396226415094
CV1107 n1107 0 53.9929065786694
LB1107 n1107 0 0.0909090909090909
CV1108 n1108 0 56.0261011310411
LB1108 n1108 0 0.087719298245614
CV1109 n1109 0 58.0594754104999
LB1109 n1109 0 0.0847457627118644
CV1110 n1110 0 0.754903161599437
LB1110 n1110 0 5
CV1111 n1111 0 2.34200303121848
LB1111 n1111 0 1.66666666666667
CV1112 n1112 0 4.06435698910359
LB1112 n1112 0 1
CV1113 n1113 0 5.88614921429191
LB1113 n1113 0 0.714285714285714
CV1114 n1114 0 7.76919173380349
LB1114 n1114 0 0.555555555555556
CV1115 n1115 0 9.69119123878523
LB1115 n1115 0 0.454545454545455
CV1116 n1116 0 11.6397218497772
LB1116 n1116 0 0.384615384615385
CV1117 n1117 0 13.6072845296839
LB1117 n1117 0 0.333333333333333
CV1118 n1118 0 15.5889478665074
LB1118 n1118 0 0.294117647058823
CV1119 n1119 0 17.5812705351704
LB1119 n1119 0 0.263157894736842
CV1120 n1120 0 19.5817647665972
LB1120 n1120 0 0.238095238095238
CV1121 n1121 0 21.5885941062507
LB1121 n1121 0 0.217391304347826
CV1122 n1122 0 23.6003840801314
LB1122 n1122 0 0.2
CV1123 n1123 0 25.6160950149517
LB1123 n1123 0 0.185185185185185
CV1124 n1124 0 27.6349331516802
LB1124 n1124 0 0.172413793103448
CV1125 n1125 0 29.6562871529751
LB1125 n1125 0 0.161290322580645
CV1126 n1126 0 31.6796821579387
LB1126 n1126 0 0.151515151515151
CV1127 n1127 0 33.7047462304696
LB1127 n1127 0 0.142857142857143
CV1128 n1128 0 35.7311856700379
LB1128 n1128 0 0.135135135135135
CV1129 n1129 0 37.7587667123055
LB1129 n1129 0 0.128205128205128
CV1130 n1130 0 39.7873018680464
LB1130 n1130 0 0.121951219512195
CV1131 n1131 0 41.816639650493
LB1131 n1131 0 0.116279069767442
CV1132 n1132 0 43.8466567940387
LB1132 n1132 0 0.111111111111111
CV1133 n1133 0 45.8772523168878
LB1133 n1133 0 0.106382978723404
CV1134 n1134 0 47.9083429577697
LB1134 n1134 0 0.102040816326531
CV1135 n1135 0 49.9398596436399
LB1135 n1135 0 0.0980392156862745
CV1136 n1136 0 51.9717447363155
LB1136 n1136 0 0.0943396226415094
CV1137 n1137 0 54.0039498716713
LB1137 n1137 0 0.0909090909090909
CV1138 n1138 0 56.0364342526877
LB1138 n1138 0 0.087719298245614
CV1139 n1139 0 58.0691632924318
LB1139 n1139 0 0.0847457627118644
CV1140 n1140 0 0.817394929072615
LB1140 n1140 0 5
CV1141 n1141 0 2.48491028929597
LB1141 n1141 0 1.66666666666667
CV1142 n1142 0 4.22428701859633
LB1142 n1142 0 1
CV1143 n1143 0 6.03491156438893
LB1143 n1143 0 0.714285714285714
CV1144 n1144 0 7.9006048275572
LB1144 n1144 0 0.555555555555556
CV1145 n1145 0 9.80600861398597
LB1145 n1145 0 0.454545454545455
CV1146 n1146 0 11.7400767869052
LB1146 n1146 0 0.384615384615385
CV1147 n1147 0 13.6952698318388
LB1147 n1147 0 0.333333333333333
CV1148 n1148 0 15.6663663437825
LB1148 n1148 0 0.294117647058823
CV1149 n1149 0 17.6496434076243
LB1149 n1149 0 0.263157894736842
CV1150 n1150 0 19.6423762837313
LB1150 n1150 0 0.238095238095238
CV1151 n1151 0 21.6425310451169
LB1151 n1151 0 0.217391304347826
CV1152 n1152 0 23.6485671597512
LB1152 n1152 0 0.2
CV1153 n1153 0 25.6593045578021
LB1153 n1153 0 0.185185185185185
CV1154 n1154 0 27.6738307319095
LB1154 n1154 0 0.172413793103448
CV1155 n1155 0 29.6914341143642
LB1155 n1155 0 0.161290322580645
CV1156 n1156 0 31.711555458097
LB1156 n1156 0 0.151515151515151
CV1157 n1157 0 33.7337519198819
LB1157 n1157 0 0.142857142857143
CV1158 n1158 0 35.7576702790112
LB1158 n1158 0 0.135135135135135
CV1159 n1159 0 37.7830268114921
LB1159 n1159 0 0.128205128205128
CV1160 n1160 0 39.8095920586352
LB1160 n1160 0 0.121951219512195
CV1161 n1161 0 41.8371792221356
LB1161 n1161 0 0.116279069767442
CV1162 n1162 0 43.8656352641411
LB1162 n1162 0 0.111111111111111
CV1163 n1163 0 45.8948340376533
LB1163 n1163 0 0.106382978723404
CV1164 n1164 0 47.9246709502296
LB1164 n1164 0 0.102040816326531
CV1165 n1165 0 49.9550587926762
LB1165 n1165 0 0.0980392156862745
CV1166 n1166 0 51.9859244582519
LB1166 n1166 0 0.0943396226415094
CV1167 n1167 0 54.0172063466702
LB1167 n1167 0 0.0909090909090909
CV1168 n1168 0 56.0488522978497
LB1168 n1168 0 0.087719298245614
CV1169 n1169 0 58.0808179378782
LB1169 n1169 0 0.0847457627118644
CV1170 n1170 0 0.854547948063785
LB1170 n1170 0 5
CV1171 n1171 0 2.58042458229434
LB1171 n1171 0 1.66666666666667
CV1172 n1172 0 4.3475553058487
LB1172 n1172 0 1
CV1173 n1173 0 6.16312217848749
LB1173 n1173 0 0.714285714285714
CV1174 n1174 0 8.02265163942696
LB1174 n1174 0 0.555555555555556
CV1175 n1175 0 9.91792781013032
LB1175 n1175 0 0.454545454545455
CV1176 n1176 0 11.8411218871624
LB1176 n1176 0 0.384615384615385
CV1177 n1177 0 13.7859373946294
LB1177 n1177 0 0.333333333333333
CV1178 n1178 0 15.7475684476268
LB1178 n1178 0 0.294117647058823
CV1179 n1179 0 17.7223832178864
LB1179 n1179 0 0.263157894736842
CV1180 n1180 0 19.7076236433475
LB1180 n1180 0 0.238095238095238
CV1181 n1181 0 21.7011765356792
LB1181 n1181 0 0.217391304347826
CV1182 n1182 0 23.7014080755431
LB1182 n1182 0 0.2
CV1183 n1183 0 25.7070445787064
LB1183 n1183 0 0.185185185185185
CV1184 n1184 0 27.7170856441895
LB1184 n1184 0 0.172413793103448
CV1185 n1185 0 29.7307400459387
LB1185 n1185 0 0.161290322580645
CV1186 n1186 0 31.7473778615141
LB1186 n1186 0 0.151515151515151
CV1187 n1187 0 33.7664943898863
LB1187 n1187 0 0.142857142857143
CV1188 n1188 0 35.7876827473661
LB1188 n1188 0 0.135135135135135
CV1189 n1189 0 37.8106129186625
LB1189 n1189 0 0.128205128205128
CV1190 n1190 0 39.8350156480115
LB1190 n1190 0 0.121951219512195
CV1191 n1191 0 41.8606699828924
LB1191 n1191 0 0.116279069767442
CV1192 n1192 0 43.8873935896605
LB1192 n1192 0 0.111111111111111
CV1193 n1193 0 45.9150351836893
LB1193 n1193 0 0.106382978723404
CV1194 n1194 0 47.9434685806262
LB1194 n1194 0 0.102040816326531
CV1195 n1195 0 49.9725879966806
LB1195 n1195 0 0.0980392156862745
CV1196 n1196 0 52.0023043160571
LB1196 n1196 0 0.0943396226415094
CV1197 n1197 0 54.032542111011
LB1197 n1197 0 0.0909090909090909
CV1198 n1198 0 56.0632372505199
LB1198 n1198 0 0.087719298245614
CV1199 n1199 0 58.0943349716086
LB1199 n1199 0 0.0847457627118644
CV1200 n1200 0 0.879437411803427
LB1200 n1200 0 5
CV1201 n1201 0 2.64807615975477
LB1201 n1201 0 1.66666666666667
CV1202 n1202 0 4.44226806469975
LB1202 n1202 0 1
CV1203 n1203 0 6.26966489261977
LB1203 n1203 0 0.714285714285714
CV1204 n1204 0 8.13068767651613
LB1204 n1204 0 0.555555555555556
CV1205 n1205 0 10.0218076040182
LB1205 n1205 0 0.454545454545455
CV1206 n1206 0 11.9382570944127
LB1206 n1206 0 0.384615384615385
CV1207 n1207 0 13.8754314193461
LB1207 n1207 0 0.333333333333333
CV1208 n1208 0 15.8293828376236
LB1208 n1208 0 0.294117647058823
CV1209 n1209 0 17.7968882285163
LB1209 n1209 0 0.263157894736842
CV1210 n1210 0 19.7753661360226
LB1210 n1210 0 0.238095238095238
CV1211 n1211 0 21.7627613514483
LB1211 n1211 0 0.217391304347826
CV1212 n1212 0 23.7574377843225
LB1212 n1212 0 0.2
CV1213 n1213 0 25.7580897189118
LB1213 n1213 0 0.185185185185185
CV1214 n1214 0 27.7636712627197
LB1214 n1214 0 0.172413793103448
CV1215 n1215 0 29.7733410891337
LB1215 n1215 0 0.161290322580645
CV1216 n1216 0 31.7864193538434
LB1216 n1216 0 0.151515151515151
CV1217 n1217 0 33.802354111535
LB1217 n1217 0 0.142857142857143
CV1218 n1218 0 35.8206950971564
LB1218 n1218 0 0.135135135135135
CV1219 n1219 0 37.8410732072858
LB1219 n1219 0 0.128205128205128
CV1220 n1220 0 39.8631843956239
LB1220 n1220 0 0.121951219512195
CV1221 n1221 0 41.886776991776
LB1221 n1221 0 0.116279069767442
CV1222 n1222 0 43.9116416802707
LB1222 n1222 0 0.111111111111111
CV1223 n1223 0 45.9376035518733
LB1223 n1223 0 0.106382978723404
CV1224 n1224 0 47.9645157736967
LB1224 n1224 0 0.102040816326531
CV1225 n1225 0 49.9922545277741
LB1225 n1225 0 0.0980392156862745
CV1226 n1226 0 52.0207149469218
LB1226 n1226 0 0.0943396226415094
CV1227 n1227 0 54.0498078375064
LB1227 n1227 0 0.0909090909090909
CV1228 n1228 0 56.0794570254493
LB1228 n1228 0 0.087719298245614
CV1229 n1229 0 58.1095971977604
LB1229 n1229 0 0.0847457627118644
CV1230 n1230 0 0.897404584100351
LB1230 n1230 0 5
CV1231 n1231 0 2.69841623101766
LB1231 n1231 0 1.66666666666667
CV1232 n1232 0 4.51628281266706
LB1232 n1232 0 1
CV1233 n1233 0 6.35750671201205
LB1233 n1233 0 0.714285714285714
CV1234 n1234 0 8.22423543794174
LB1234 n1234 0 0.555555555555556
CV1235 n1235 0 10.1155236411052
LB1235 n1235 0 0.454545454545455
CV1236 n1236 0 12.0288339565437
LB1236 n1236 0 0.384615384615385
CV1237 n1237 0 13.9611177455842
LB1237 n1237 0 0.333333333333333
CV1238 n1238 0 15.9094023293827
LB1238 n1238 0 0.294117647058823
CV1239 n1239 0 17.8710391297204
LB1239 n1239 0 0.263157894736842
CV1240 n1240 0 19.8437699417801
LB1240 n1240 0 0.238095238095238
CV1241 n1241 0 21.8257114471054
LB1241 n1241 0 0.217391304347826
CV1242 n1242 0 23.8153098685385
LB1242 n1242 0 0.2
CV1243 n1243 0 25.8112893958119
LB1243 n1243 0 0.185185185185185
CV1244 n1244 0 27.812603906976
LB1244 n1244 0 0.172413793103448
CV1245 n1245 0 29.8183951150409
LB1245 n1245 0 0.161290322580645
CV1246 n1246 0 31.827957580039
LB1246 n1246 0 0.151515151515151
CV1247 n1247 0 33.8407100024378
LB1247 n1247 0 0.142857142857143
CV1248 n1248 0 35.8561719037315
LB1248 n1248 0 0.135135135135135
CV1249 n1249 0 37.8739447817601
LB1249 n1249 0 0.128205128205128
CV1250 n1250 0 39.8936969189043
LB1250 n1250 0 0.121951219512195
CV1251 n1251 0 41.9151511430067
LB1251 n1251 0 0.116279069767442
CV1252 n1252 0 43.9380749617256
LB1252 n1252 0 0.111111111111111
CV1253 n1253 0 45.9622725989836
LB1253 n1253 0 0.106382978723404
CV1254 n1254 0 47.9875785538736
LB1254 n1254 0 0.102040816326531
CV1255 n1255 0 50.0138523781151
LB1255 n1255 0 0.0980392156862745
CV1256 n1256 0 52.0409744296598
LB1256 n1256 0 0.0943396226415094
CV1257 n1257 0 54.0688424094553
LB1257 n1257 0 0.0909090909090909
CV1258 n1258 0 56.0973685278105
LB1258 n1258 0 0.087719298245614
CV1259 n1259 0 58.1264771781356
LB1259 n1259 0 0.0847457627118644
CV1260 n1260 0 0.91105125838875
LB1260 n1260 0 5
CV1261 n1261 0 2.73735356602757
LB1261 n1261 0 1.66666666666667
CV1262 n1262 0 4.57534763515195
LB1262 n1262 0 1
CV1263 n1263 0 6.43025275997867
LB1263 n1263 0 0.714285714285714
CV1264 n1264 0 8.30462954165229
LB1264 n1264 0 0.555555555555556
CV1265 n1265 0 10.1988191019818
LB1265 n1265 0 0.454545454545455
CV1266 n1266 0 12.1117147193383
LB1266 n1266 0 0.384615384615385
CV1267 n1267 0 14.0414720723069
LB1267 n1267 0 0.333333333333333
CV1268 n1268 0 15.9860033466713
LB1268 n1268 0 0.294117647058823
CV1269 n1269 0 17.9432618048995
LB1269 n1269 0 0.263157894736842
CV1270 n1270 0 19.9113788948593
LB1270 n1270 0 0.238095238095238
CV1271 n1271 0 21.8887139393526
LB1271 n1271 0 0.217391304347826
CV1272 n1272 0 23.8738579746358
LB1272 n1272 0 0.2
CV1273 n1273 0 25.865616345918
LB1273 n1273 0 0.185185185185185
CV1274 n1274 0 27.8629833058239
LB1274 n1274 0 0.172413793103448
CV1275 n1275 0 29.8651152342124
LB1275 n1275 0 0.161290322580645
CV1276 n1276 0 31.8713055140094
LB1276 n1276 0 0.151515151515151
CV1277 n1277 0 33.880962252924
LB1277 n1277 0 0.142857142857143
CV1278 n1278 0 35.8935891317568
LB1278 n1278 0 0.135135135135135
CV1279 n1279 0 37.9087692380275
LB1279 n1279 0 0.128205128205128
CV1280 n1280 0 39.9261515698029
LB1280 n1280 0 0.121951219512195
CV1281 n1281 0 41.94543984411
LB1281 n1281 0 0.116279069767442
CV1282 n1282 0 43.9663832525907
LB1282 n1282 0 0.111111111111111
CV1283 n1283 0 45.9887688408676
LB1283 n1283 0 0.106382978723404
CV1284 n1284 0 48.0124152305927
LB1284 n1284 0 0.102040816326531
CV1285 n1285 0 50.0371674460329
LB1285 n1285 0 0.0980392156862745
CV1286 n1286 0 52.0628926465181
LB1286 n1286 0 0.0943396226415094
CV1287 n1287 0 54.0894766006764
LB1287 n1287 0 0.0909090909090909
CV1288 n1288 0 56.1168207678429
LB1288 n1288 0 0.087719298245614
CV1289 n1289 0 58.1448398766541
LB1289 n1289 0 0.0847457627118644
CV1290 n1290 0 0.921804624800045
LB1290 n1290 0 5
CV1291 n1291 0 2.76839806180029
LB1291 n1291 0 1.66666666666667
CV1292 n1292 0 4.62343595213312
LB1292 n1292 0 1
CV1293 n1293 0 6.49105618679175
LB1293 n1293 0 0.714285714285714
CV1294 n1294 0 8.37372927891669
LB1294 n1294 0 0.555555555555556
CV1295 n1295 0 10.2723732144046
LB1295 n1295 0 0.454545454545455
CV1296 n1296 0 12.1867322680544
LB1296 n1296 0 0.384615384615385
CV1297 n1297 0 14.1158100406555
LB1297 n1297 0 0.333333333333333
CV1298 n1298 0 16.058231172571
LB1298 n1298 0 0.294117647058823
CV1299 n1299 0 18.0124931182668
LB1299 n1299 0 0.263157894736842
CV1300 n1300 0 19.9771189682669
LB1300 n1300 0 0.238095238095238
CV1301 n1301 0 21.950738469946
LB1301 n1301 0 0.217391304347826
CV1302 n1302 0 23.932123147967
LB1302 n1302 0 0.2
CV1303 n1303 0 25.9201946747814
LB1303 n1303 0 0.185185185185185
CV1304 n1304 0 27.9140189660515
LB1304 n1304 0 0.172413793103448
CV1305 n1305 0 29.9127935205456
LB1305 n1305 0 0.161290322580645
CV1306 n1306 0 31.9158322839961
LB1306 n1306 0 0.151515151515151
CV1307 n1307 0 33.9225503400094
LB1307 n1307 0 0.142857142857143
CV1308 n1308 0 35.9324495768491
LB1308 n1308 0 0.135135135135135
CV1309 n1309 0 37.9451058268422
LB1309 n1309 0 0.128205128205128
CV1310 n1310 0 39.9601576193257
LB1310 n1310 0 0.121951219512195
CV1311 n1311 0 41.977296503213
LB1311 n1311 0 0.116279069767442
CV1312 n1312 0 43.9962588073834
LB1312 n1312 0 0.111111111111111
CV1313 n1313 0 46.0168186730643
LB1313 n1313 0 0.106382978723404
CV1314 n1314 0 48.0387821872719
LB1314 n1314 0 0.102040816326531
CV1315 n1315 0 50.0619824559336
LB1315 n1315 0 0.0980392156862745
CV1316 n1316 0 52.0862754714627
LB1316 n1316 0 0.0943396226415094
CV1317 n1317 0 54.1115366478321
LB1317 n1317 0 0.0909090909090909
CV1318 n1318 0 56.1376579142328
LB1318 n1318 0 0.087719298245614
CV1319 n1319 0 58.1645452750375
LB1319 n1319 0 0.0847457627118644
CV1320 n1320 0 0.930517198298853
LB1320 n1320 0 5
CV1321 n1321 0 2.79375319722567
LB1321 n1321 0 1.66666666666667
CV1322 n1322 0 4.66329132051969
LB1322 n1322 0 1
CV1323 n1323 0 6.54242225889851
LB1323 n1323 0 0.714285714285714
CV1324 n1324 0 8.43335920574106
LB1324 n1324 0 0.555555555555556
CV1325 n1325 0 10.3372308752131
LB1325 n1325 0 0.454545454545455
CV1326 n1326 0 12.2542581747132
LB1326 n1326 0 0.384615384615385
CV1327 n1327 0 14.1840074014681
LB1327 n1327 0 0.333333333333333
CV1328 n1328 0 16.1256368642615
LB1328 n1328 0 0.294117647058823
CV1329 n1329 0 18.0780947994691
LB1329 n1329 0 0.263157894736842
CV1330 n1330 0 20.0402588612137
LB1330 n1330 0 0.238095238095238
CV1331 n1331 0 22.011024604383
LB1331 n1331 0 0.217391304347826
CV1332 n1332 0 23.9893558653423
LB1332 n1332 0 0.2
CV1333 n1333 0 25.9743093488381
LB1333 n1333 0 0.185185185185185
CV1334 n1334 0 27.9650429998142
LB1334 n1334 0 0.172413793103448
CV1335 n1335 0 29.9608148591734
LB1335 n1335 0 0.161290322580645
CV1336 n1336 0 31.960976784302
LB1336 n1336 0 0.151515151515151
CV1337 n1337 0 33.9649657615776
LB1337 n1337 0 0.142857142857143
CV1338 n1338 0 35.9722944353768
LB1338 n1338 0 0.135135135135135
CV1339 n1339 0 37.982541773411
LB1339 n1339 0 0.128205128205128
CV1340 n1340 0 39.9953443516766
LB1340 n1340 0 0.121951219512195
CV1341 n1341 0 42.0103884793196
LB1341 n1341 0 0.116279069767442
CV1342 n1342 0 44.0274032302578
LB1342 n1342 0 0.111111111111111
CV1343 n1343 0 46.0461543627817
LB1343 n1343 0 0.106382978723404
CV1344 n1344 0 48.0664390640342
LB1344 n1344 0 0.102040816326531
CV1345 n1345 0 50.0880814365706
LB1345 n1345 0 0.0980392156862745
CV1346 n1346 0 52.1109286387793
LB1346 n1346 0 0.0943396226415094
CV1347 n1347 0 54.1348475934234
LB1347 n1347 0 0.0909090909090909
CV1348 n1348 0 56.1597221850879
LB1348 n1348 0 0.087719298245614
CV1349 n1349 0 58.1854508755913
LB1349 n1349 0 0.0847457627118644
CV1350 n1350 0 0.937731863834988
LB1350 n1350 0 5
CV1351 n1351 0 2.81486937068669
LB1351 n1351 0 1.66666666666667
CV1352 n1352 0 4.69683857017632
LB1352 n1352 0 1
CV1353 n1353 0 6.58627951337829
LB1353 n1353 0 0.714285714285714
CV1354 n1354 0 8.48511527190943
LB1354 n1354 0 0.555555555555556
CV1355 n1355 0 10.394504540034
LB1355 n1355 0 0.454545454545455
CV1356 n1356 0 12.3149167035312
LB1356 n1356 0 0.384615384615385
CV1357 n1357 0 14.2462754870976
LB1357 n1357 0 0.333333333333333
CV1358 n1358 0 16.1881203835689
LB1358 n1358 0 0.294117647058823
CV1359 n1359 0 18.1397524560681
LB1359 n1359 0 0.263157894736842
CV1360 n1360 0 20.1003495261332
LB1360 n1360 0 0.238095238095238
CV1361 n1361 0 22.0690486489105
LB1361 n1361 0 0.217391304347826
CV1362 n1362 0 24.0450003655555
LB1362 n1362 0 0.2
CV1363 n1363 0 26.0274013338771
LB1363 n1363 0 0.185185185185185
CV1364 n1364 0 28.0155116602617
LB1364 n1364 0 0.172413793103448
CV1365 n1365 0 30.0086620534284
LB1365 n1365 0 0.161290322580645
CV1366 n1366 0 32.0062545798
LB1366 n1366 0 0.151515151515151
CV1367 n1367 0 34.0077596482631
LB1367 n1367 0 0.142857142857143
CV1368 n1368 0 36.0127109722553
LB1368 n1368 0 0.135135135135135
CV1369 n1369 0 38.0206996285161
LB1369 n1369 0 0.128205128205128
CV1370 n1370 0 40.0313679015766
LB1370 n1370 0 0.121951219512195
CV1371 n1371 0 42.0444033175062
LB1371 n1371 0 0.116279069767442
CV1372 n1372 0 44.0595330857573
LB1372 n1372 0 0.111111111111111
CV1373 n1373 0 46.0765190515124
LB1373 n1373 0 0.106382978723404
CV1374 n1374 0 48.0951531897381
LB1374 n1374 0 0.102040816326531
CV1375 n1375 0 50.1152536303851
LB1375 n1375 0 0.0980392156862745
CV1376 n1376 0 52.1366611812591
LB1376 n1376 0 0.0943396226415094
CV1377 n1377 0 54.1592363039936
LB1377 n1377 0 0.0909090909090909
CV1378 n1378 0 56.1828564946995
LB1378 n1378 0 0.087719298245614
CV1379 n1379 0 58.2074140212664
LB1379 n1379 0 0.0847457627118644
CV1380 n1380 0 0.943811956344319
LB1380 n1380 0 5
CV1381 n1381 0 2.8327399916739
LB1381 n1381 0 1.66666666666667
CV1382 n1382 0 4.72545651254794
LB1382 n1382 0 1
CV1383 n1383 0 6.62410232669201
LB1383 n1383 0 0.714285714285714
CV1384 n1384 0 8.53032801097994
LB1384 n1384 0 0.555555555555556
CV1385 n1385 0 10.4452381165545
LB1385 n1385 0 0.454545454545455
CV1386 n1386 0 12.3694162193477
LB1386 n1386 0 0.384615384615385
CV1387 n1387 0 14.3030038840728
LB1387 n1387 0 0.333333333333333
CV1388 n1388 0 16.2458035726856
LB1388 n1388 0 0.294117647058823
CV1389 n1389 0 18.1973819461033
LB1389 n1389 0 0.263157894736842
CV1390 n1390 0 20.1571595962748
LB1390 n1390 0 0.238095238095238
CV1391 n1391 0 22.1244816241374
LB1391 n1391 0 0.217391304347826
CV1392 n1392 0 24.0986689817776
LB1392 n1392 0 0.2
CV1393 n1393 0 26.0790532753137
LB1393 n1393 0 0.185185185185185
CV1394 n1394 0 28.0649986237623
LB1394 n1394 0 0.172413793103448
CV1395 n1395 0 30.0559140352054
LB1395 n1395 0 0.161290322580645
CV1396 n1396 0 32.0512591916695
LB1396 n1396 0 0.151515151515151
CV1397 n1397 0 34.0505458682623
LB1397 n1397 0 0.142857142857143
CV1398 n1398 0 36.0533366089141
LB1398 n1398 0 0.135135135135135
CV1399 n1399 0 38.0592417944415
LB1399 n1399 0 0.128205128205128
CV1400 n1400 0 40.0679158713407
LB1400 n1400 0 0.121951219512195
CV1401 n1401 0 42.079053244215
LB1401 n1401 0 0.116279069767442
CV1402 n1402 0 44.092384148711
LB1402 n1402 0 0.111111111111111
CV1403 n1403 0 46.1076706947115
LB1403 n1403 0 0.106382978723404
CV1404 n1404 0 48.1247031846301
LB1404 n1404 0 0.102040816326531
CV1405 n1405 0 50.14329675629
LB1405 n1405 0 0.0980392156862745
CV1406 n1406 0 52.1632883648038
LB1406 n1406 0 0.0943396226415094
CV1407 n1407 0 54.1845340965191
LB1407 n1407 0 0.0909090909090909
CV1408 n1408 0 56.2069067958553
LB1408 n1408 0 0.087719298245614
CV1409 n1409 0 58.2302939795633
LB1409 n1409 0 0.0847457627118644
CV1410 n1410 0 0.949010495013647
LB1410 n1410 0 5
CV1411 n1411 0 2.84806855981932
LB1411 n1411 0 1.66666666666667
CV1412 n1412 0 4.75015404493148
LB1412 n1412 0 1
CV1413 n1413 0 6.65702209017161
LB1413 n1413 0 0.714285714285714
CV1414 n1414 0 8.5700842572692
LB1414 n1414 0 0.555555555555556
CV1415 n1415 0 10.4903561688689
LB1415 n1415 0 0.454545454545455
CV1416 n1416 0 12.4184587281525
LB1416 n1416 0 0.384615384615385
CV1417 n1417 0 14.3546595549142
LB1417 n1417 0 0.333333333333333
CV1418 n1418 0 16.2989372392995
LB1418 n1418 0 0.294117647058823
CV1419 n1419 0 18.2510527075287
LB1419 n1419 0 0.263157894736842
CV1420 n1420 0 20.2106166106385
LB1420 n1420 0 0.238095238095238
CV1421 n1421 0 22.1771466495304
LB1421 n1421 0 0.217391304347826
CV1422 n1422 0 24.1501127066292
LB1422 n1422 0 0.2
CV1423 n1423 0 26.1289701677477
LB1423 n1423 0 0.185185185185185
CV1424 n1424 0 28.1131830842296
LB1424 n1424 0 0.172413793103448
CV1425 n1425 0 30.1022392403317
LB1425 n1425 0 0.161290322580645
CV1426 n1426 0 32.095659122783
LB1426 n1426 0 0.151515151515151
CV1427 n1427 0 34.0930005017555
LB1427 n1427 0 0.142857142857143
CV1428 n1428 0 36.0938599830255
LB1428 n1428 0 0.135135135135135
CV1429 n1429 0 38.0978725605359
LB1429 n1429 0 0.128205128205128
CV1430 n1430 0 40.1047099197213
LB1430 n1430 0 0.121951219512195
CV1431 n1431 0 42.1140780218446
LB1431 n1431 0 0.116279069767442
CV1432 n1432 0 44.1257143332649
LB1432 n1432 0 0.111111111111111
CV1433 n1433 0 46.1393849417459
LB1433 n1433 0 0.106382978723404
CV1434 n1434 0 48.1548817148934
LB1434 n1434 0 0.102040816326531
CV1435 n1435 0 50.1720195949604
LB1435 n1435 0 0.0980392156862745
CV1436 n1436 0 52.1906340825907
LB1436 n1436 0 0.0943396226415094
CV1437 n1437 0 54.210578934182
LB1437 n1437 0 0.0909090909090909
CV1438 n1438 0 56.2317240793864
LB1438 n1438 0 0.087719298245614
CV1439 n1439 0 58.2539537538741
LB1439 n1439 0 0.0847457627118644
CV1440 n1440 0 0.9535094854036
LB1440 n1440 0 5
CV1441 n1441 0 2.86136752694328
LB1441 n1441 0 1.66666666666667
CV1442 n1442 0 4.77168438012327
LB1442 n1442 0 1
CV1443 n1443 0 6.68591432394119
LB1443 n1443 0 0.714285714285714
CV1444 n1444 0 8.60526542018822
LB1444 n1444 0 0.555555555555556
CV1445 n1445 0 10.5306542244789
LB1445 n1445 0 0.454545454545455
CV1446 n1446 0 12.4626963806127
LB1446 n1446 0 0.384615384615385
CV1447 n1447 0 14.4017265690031
LB1447 n1447 0 0.333333333333333
CV1448 n1448 0 16.3478377822069
LB1448 n1448 0 0.294117647058823
CV1449 n1449 0 18.3009297467993
LB1449 n1449 0 0.263157894736842
CV1450 n1450 0 20.260758319516
LB1450 n1450 0 0.238095238095238
CV1451 n1451 0 22.2269804902867
LB1451 n1451 0 0.217391304347826
CV1452 n1452 0 24.1991922387586
LB1452 n1452 0 0.2
CV1453 n1453 0 26.1769584448117
LB1453 n1453 0 0.185185185185185
CV1454 n1454 0 28.1598352729224
LB1454 n1454 0 0.172413793103448
CV1455 n1455 0 30.1473860666065
LB1455 n1455 0 0.161290322580645
CV1456 n1456 0 32.1391919934643
LB1456 n1456 0 0.151515151515151
CV1457 n1457 0 34.1348586447093
LB1457 n1457 0 0.142857142857143
CV1458 n1458 0 36.1340196396259
LB1458 n1458 0 0.135135135135135
CV1459 n1459 0 38.1363380930414
LB1459 n1459 0 0.128205128205128
CV1460 n1460 0 40.1415066153487
LB1460 n1460 0 0.121951219512195
CV1461 n1461 0 42.149246349604
LB1461 n1461 0 0.116279069767442
CV1462 n1462 0 44.1593054150593
LB1462 n1462 0 0.111111111111111
CV1463 n1463 0 46.1714570205021
LB1463 n1463 0 0.106382978723404
CV1464 n1464 0 48.1854974302585
LB1464 n1464 0 0.102040816326531
CV1465 n1465 0 50.2012439060212
LB1465 n1465 0 0.0980392156862745
CV1466 n1466 0 52.2185327043248
LB1466 n1466 0 0.0943396226415094
CV1467 n1467 0 54.237217178615
LB1467 n1467 0 0.0909090909090909
CV1468 n1468 0 56.2571660132842
LB1468 n1468 0 0.087719298245614
CV1469 n1469 0 58.2782616022957
LB1469 n1469 0 0.0847457627118644
CV1470 n1470 0 0.957443430629066
LB1470 n1470 0 5
CV1471 n1471 0 2.87301927181394
LB1471 n1471 0 1.66666666666667
CV1472 n1472 0 4.79062030381396
LB1472 n1472 0 1
CV1473 n1473 0 6.7114635549321
LB1473 n1473 0 0.714285714285714
CV1474 n1474 0 8.63658604378135
LB1474 n1474 0 0.555555555555556
CV1475 n1475 0 10.566806980733
LB1475 n1475 0 0.454545454545455
CV1476 n1476 0 12.5027143242884
LB1476 n1476 0 0.384615384615385
CV1477 n1477 0 14.4446726107383
LB1477 n1477 0 0.333333333333333
CV1478 n1478 0 16.3928463032174
LB1478 n1478 0 0.294117647058823
CV1479 n1479 0 18.3472321573759
LB1479 n1479 0 0.263157894736842
CV1480 n1480 0 20.3076948173024
LB1480 n1480 0 0.238095238095238
CV1481 n1481 0 22.2740013360658
LB1481 n1481 0 0.217391304347826
CV1482 n1482 0 24.245851944745
LB1482 n1482 0 0.2
CV1483 n1483 0 26.2229057893085
LB1483 n1483 0 0.185185185185185
CV1484 n1484 0 28.2048013630494
LB1484 n1484 0 0.172413793103448
CV1485 n1485 0 30.191171986009
LB1485 n1485 0 0.161290322580645
CV1486 n1486 0 32.18165699971
LB1486 n1486 0 0.151515151515151
CV1487 n1487 0 34.175909451466
LB1487 n1487 0 0.142857142857143
CV1488 n1488 0 36.1736010216013
LB1488 n1488 0 0.135135135135135
CV1489 n1489 0 38.1744248610617
LB1489 n1489 0 0.128205128205128
CV1490 n1490 0 40.1780968965207
LB1490 n1490 0 0.121951219512195
CV1491 n1491 0 42.1843560486735
LB1491 n1491 0 0.116279069767442
CV1492 n1492 0 44.1929637088793
LB1492 n1492 0 0.111111111111111
CV1493 n1493 0 46.2037027343558
LB1493 n1493 0 0.106382978723404
CV1494 n1494 0 48.2163761534222
LB1494 n1494 0 0.102040816326531
CV1495 n1495 0 50.230805718426
LB1495 n1495 0 0.0980392156862745
CV1496 n1496 0 52.2468304027995
LB1496 n1496 0 0.0943396226415094
CV1497 n1497 0 54.2643049078162
LB1497 n1497 0 0.0909090909090909
CV1498 n1498 0 56.2830982218886
LB1498 n1498 0 0.087719298245614
CV1499 n1499 0 58.3030922588018
LB1499 n1499 0 0.0847457627118644
CV1500 n1500 0 0.960914020795729
LB1500 n1500 0 5
CV1501 n1501 0 2.88331508861242
LB1501 n1501 0 1.66666666666667
CV1502 n1502 0 4.80740472217132
LB1502 n1502 0 1
CV1503 n1503 0 6.7342108165031
LB1503 n1503 0 0.714285714285714
CV1504 n1504 0 8.66462727564599
LB1504 n1504 0 0.555555555555556
CV1505 n1505 0 10.5993829686172
LB1505 n1505 0 0.454545454545455
CV1506 n1506 0 12.5390274574135
LB1506 n1506 0 0.384615384615385
CV1507 n1507 0 14.4839321495531
LB1507 n1507 0 0.333333333333333
CV1508 n1508 0 16.4343035895364
LB1508 n1508 0 0.294117647058823
CV1509 n1509 0 18.3902047672533
LB1509 n1509 0 0.263157894736842
CV1510 n1510 0 20.3515804375141
LB1510 n1510 0 0.238095238095238
CV1511 n1511 0 22.3182831685554
LB1511 n1511 0 0.217391304347826
CV1512 n1512 0 24.2900978060804
LB1512 n1512 0 0.2
CV1513 n1513 0 26.2667629817379
LB1513 n1513 0 0.185185185185185
CV1514 n1514 0 28.2479890611779
LB1514 n1514 0 0.172413793103448
CV1515 n1515 0 30.233472469045
LB1515 n1515 0 0.161290322580645
CV1516 n1516 0 32.2229066623204
LB1516 n1516 0 0.151515151515151
CV1517 n1517 0 34.2159901940472
LB1517 n1517 0 0.142857142857143
CV1518 n1518 0 36.2124323667768
LB1518 n1518 0 0.135135135135135
CV1519 n1519 0 38.2119569624408
LB1519 n1519 0 0.128205128205128
CV1520 n1520 0 40.2143044852487
LB1520 n1520 0 0.121951219512195
CV1521 n1521 0 42.219233288526
LB1521 n1521 0 0.116279069767442
CV1522 n1522 0 44.2265198884778
LB1522 n1522 0 0.111111111111111
CV1523 n1523 0 46.2359587049693
LB1523 n1523 0 0.106382978723404
CV1524 n1524 0 48.2473614148535
LB1524 n1524 0 0.102040816326531
CV1525 n1525 0 50.2605560580536
LB1525 n1525 0 0.0980392156862745
CV1526 n1526 0 52.2753860001292
LB1526 n1526 0 0.0943396226415094
CV1527 n1527 0 54.2917088263924
LB1527 n1527 0 0.0909090909090909
CV1528 n1528 0 56.309395220565
LB1528 n1528 0 0.087719298245614
CV1529 n1529 0 58.3283278642553
LB1529 n1529 0 0.0847457627118644
CV1530 n1530 0 0.963999652871862
LB1530 n1530 0 5
CV1531 n1531 0 2.89248091289263
LB1531 n1531 0 1.66666666666667
CV1532 n1532 0 4.82238529870442
LB1532 n1532 0 1
CV1533 n1533 0 6.75458834039299
LB1533 n1533 0 0.714285714285714
CV1534 n1534 0 8.68986420543776
LB1534 n1534 0 0.555555555555556
CV1535 n1535 0 10.6288603638759
LB1535 n1535 0 0.454545454545455
CV1536 n1536 0 12.5720839747393
LB1536 n1536 0 0.384615384615385
CV1537 n1537 0 14.5198995083014
LB1537 n1537 0 0.333333333333333
CV1538 n1538 0 16.4725357443983
LB1538 n1538 0 0.294117647058823
CV1539 n1539 0 18.4300995447786
LB1539 n1539 0 0.263157894736842
CV1540 n1540 0 20.3925936617911
LB1540 n1540 0 0.238095238095238
CV1541 n1541 0 22.3599361549868
LB1541 n1541 0 0.217391304347826
CV1542 n1542 0 24.3319795361649
LB1542 n1542 0 0.2
CV1543 n1543 0 26.3085283732648
LB1543 n1543 0 0.185185185185185
CV1544 n1544 0 28.289354634574
LB1544 n1544 0 0.172413793103448
CV1545 n1545 0 30.2742104880632
LB1545 n1545 0 0.161290322580645
CV1546 n1546 0 32.2628385733004
LB1546 n1546 0 0.151515151515151
CV1547 n1547 0 34.254979949594
LB1547 n1547 0 0.142857142857143
CV1548 n1548 0 36.2503800195527
LB1548 n1548 0 0.135135135135135
CV1549 n1549 0 38.2487927593395
LB1549 n1549 0 0.128205128205128
CV1550 n1550 0 40.2499835788815
LB1550 n1550 0 0.121951219512195
CV1551 n1551 0 42.2537311049632
LB1551 n1551 0 0.116279069767442
CV1552 n1552 0 44.259828139754
LB1552 n1552 0 0.111111111111111
CV1553 n1553 0 46.2680820047279
LB1553 n1553 0 0.106382978723404
CV1554 n1554 0 48.2783144396327
LB1554 n1554 0 0.102040816326531
CV1555 n1555 0 50.2903611904032
LB1555 n1555 0 0.0980392156862745
CV1556 n1556 0 52.3040713895282
LB1556 n1556 0 0.0943396226415094
CV1557 n1557 0 54.3193068073418
LB1557 n1557 0 0.0909090909090909
CV1558 n1558 0 56.3359410325857
LB1558 n1558 0 0.087719298245614
CV1559 n1559 0 58.3538586247077
LB1559 n1559 0 0.0847457627118644
CV1560 n1560 0 0.966761796077371
LB1560 n1560 0 5
CV1561 n1561 0 2.90069476991398
LB1561 n1561 0 1.66666666666667
CV1562 n1562 0 4.83583865399482
LB1562 n1562 0 1
CV1563 n1563 0 6.77294500940971
LB1563 n1563 0 0.714285714285714
CV1564 n1564 0 8.71268759040376
LB1564 n1564 0 0.555555555555556
CV1565 n1565 0 10.655641692658
LB1565 n1565 0 0.454545454545455
CV1566 n1566 0 12.6022718119737
LB1566 n1566 0 0.384615384615385
CV1567 n1567 0 14.5529275443249
LB1567 n1567 0 0.333333333333333
CV1568 n1568 0 16.5078466919882
LB1568 n1568 0 0.294117647058823
CV1569 n1569 0 18.4671639380219
LB1569 n1569 0 0.263157894736842
CV1570 n1570 0 20.4309232317307
LB1570 n1570 0 0.238095238095238
CV1571 n1571 0 22.3990921205621
LB1571 n1571 0 0.217391304347826
CV1572 n1572 0 24.3715765566372
LB1572 n1572 0 0.2
CV1573 n1573 0 26.3482350863383
LB1573 n1573 0 0.185185185185185
CV1574 n1574 0 28.3288917121031
LB1574 n1574 0 0.172413793103448
CV1575 n1575 0 30.3133470435555
LB1575 n1575 0 0.161290322580645
CV1576 n1576 0 32.3013876073095
LB1576 n1576 0 0.151515151515151
CV1577 n1577 0 34.2927933594474
LB1577 n1577 0 0.142857142857143
CV1578 n1578 0 36.2873435521243
LB1578 n1578 0 0.135135135135135
CV1579 n1579 0 38.2848211610819
LB1579 n1579 0 0.128205128205128
CV1580 n1580 0 40.2850160993316
LB1580 n1580 0 0.121951219512195
CV1581 n1581 0 42.2877274369825
LB1581 n1581 0 0.116279069767442
CV1582 n1582 0 44.2927648281999
LB1582 n1582 0 0.111111111111111
CV1583 n1583 0 46.2999493207469
LB1583 n1583 0 0.106382978723404
CV1584 n1584 0 48.3091136961737
LB1584 n1584 0 0.102040816326531
CV1585 n1585 0 50.3201024623223
LB1585 n1585 0 0.0980392156862745
CV1586 n1586 0 52.3327715959332
LB1586 n1586 0 0.0943396226415094
CV1587 n1587 0 54.3469881124413
LB1587 n1587 0 0.0909090909090909
CV1588 n1588 0 56.362629522647
LB1588 n1588 0 0.087719298245614
CV1589 n1589 0 58.3795832216708
LB1589 n1589 0 0.0847457627118644
CV1590 n1590 0 0.969249364422904
LB1590 n1590 0 5
CV1591 n1591 0 2.90809889879279
LB1591 n1591 0 1.66666666666667
CV1592 n1592 0 4.84798758571206
LB1592 n1592 0 1
CV1593 n1593 0 6.78956517963613
LB1593 n1593 0 0.714285714285714
CV1594 n1594 0 8.7334209154172
LB1594 n1594 0 0.555555555555556
CV1595 n1595 0 10.6800666444145
LB1595 n1595 0 0.454545454545455
CV1596 n1596 0 12.6299259448472
LB1596 n1596 0 0.384615384615385
CV1597 n1597 0 14.5833293263885
LB1597 n1597 0 0.333333333333333
CV1598 n1598 0 16.5405149702386
LB1598 n1598 0 0.294117647058823
CV1599 n1599 0 18.5016339774765
LB1599 n1599 0 0.263157894736842
CV1600 n1600 0 20.4667588708409
LB1600 n1600 0 0.238095238095238
CV1601 n1601 0 22.4358940819056
LB1601 n1601 0 0.217391304347826
CV1602 n1602 0 24.4089872972786
LB1602 n1602 0 0.2
CV1603 n1603 0 26.3859407654299
LB1603 n1603 0 0.185185185185185
CV1604 n1604 0 28.3666219203072
LB1604 n1604 0 0.172413793103448
CV1605 n1605 0 30.3508729166657
LB1605 n1605 0 0.161290322580645
CV1606 n1606 0 32.3385188711917
LB1606 n1606 0 0.151515151515151
CV1607 n1607 0 34.3293747542746
LB1607 n1607 0 0.142857142857143
CV1608 n1608 0 36.3232509811538
LB1608 n1608 0 0.135135135135135
CV1609 n1609 0 38.3199578150879
LB1609 n1609 0 0.128205128205128
CV1610 n1610 0 40.3193087281788
LB1610 n1610 0 0.121951219512195
CV1611 n1611 0 42.3211228763859
LB1611 n1611 0 0.116279069767442
CV1612 n1612 0 44.3252268416458
LB1612 n1612 0 0.111111111111111
CV1613 n1613 0 46.3314557817864
LB1613 n1613 0 0.106382978723404
CV1614 n1614 0 48.339654112351
LB1614 n1614 0 0.102040816326531
CV1615 n1615 0 50.3496758264394
LB1615 n1615 0 0.0980392156862745
CV1616 n1616 0 52.3613845410274
LB1616 n1616 0 0.0943396226415094
CV1617 n1617 0 54.3746533420061
LB1617 n1617 0 0.0909090909090909
CV1618 n1618 0 56.3893644858648
LB1618 n1618 0 0.087719298245614
CV1619 n1619 0 58.4054090036976
LB1619 n1619 0 0.0847457627118644
CV1620 n1620 0 0.971501791806325
LB1620 n1620 0 5
CV1621 n1621 0 2.91480835961995
LB1621 n1621 0 1.66666666666667
CV1622 n1622 0 4.85901353230822
LB1622 n1622 0 1
CV1623 n1623 0 6.80468273179868
LB1623 n1623 0 0.714285714285714
CV1624 n1624 0 8.75233373832547
LB1624 n1624 0 0.555555555555556
CV1625 n1625 0 10.7024228725468
LB1625 n1625 0 0.454545454545455
CV1626 n1626 0 12.6553355293567
LB1626 n1626 0 0.384615384615385
CV1627 n1627 0 14.6113812575179
LB1627 n1627 0 0.333333333333333
CV1628 n1628 0 16.5707931008359
LB1628 n1628 0 0.294117647058823
CV1629 n1629 0 18.5337305601959
LB1629 n1629 0 0.263157894736842
CV1630 n1630 0 20.5002853308751
LB1630 n1630 0 0.238095238095238
CV1631 n1631 0 22.4704889100539
LB1631 n1631 0 0.217391304347826
CV1632 n1632 0 24.4443212251266
LB1632 n1632 0 0.2
CV1633 n1633 0 26.4217195635802
LB1633 n1633 0 0.185185185185185
CV1634 n1634 0 28.4025872503197
LB1634 n1634 0 0.172413793103448
CV1635 n1635 0 30.3868016869234
LB1635 n1635 0 0.161290322580645
CV1636 n1636 0 32.3742215186808
LB1636 n1636 0 0.151515151515151
CV1637 n1637 0 34.3646928186525
LB1637 n1637 0 0.142857142857143
CV1638 n1638 0 36.358054270417
LB1638 n1638 0 0.135135135135135
CV1639 n1639 0 38.3541413946012
LB1639 n1639 0 0.128205128205128
CV1640 n1640 0 40.3527899033538
LB1640 n1640 0 0.121951219512195
CV1641 n1641 0 42.3538382870905
LB1641 n1641 0 0.116279069767442
CV1642 n1642 0 44.3571297443963
LB1642 n1642 0 0.111111111111111
CV1643 n1643 0 46.3625135634261
LB1643 n1643 0 0.106382978723404
CV1644 n1644 0 48.3698460550596
LB1644 n1644 0 0.102040816326531
CV1645 n1645 0 50.3789911270665
LB1645 n1645 0 0.0980392156862745
CV1646 n1646 0 52.3898205764425
LB1646 n1646 0 0.0943396226415094
CV1647 n1647 0 54.4022141650735
LB1647 n1647 0 0.0909090909090909
CV1648 n1648 0 56.4160595326787
LB1648 n1648 0 0.087719298245614
CV1649 n1649 0 58.4312519909471
LB1649 n1649 0 0.0847457627118644
CV1650 n1650 0 0.973551239872241
LB1650 n1650 0 5
CV1651 n1651 0 2.92091726152114
LB1651 n1651 0 1.66666666666667
CV1652 n1652 0 4.86906573696457
LB1652 n1652 0 1
CV1653 n1653 0 6.81849166720773
LB1653 n1653 0 0.714285714285714
CV1654 n1654 0 8.7696521366009
LB1654 n1654 0 0.555555555555556
CV1655 n1655 0 10.7229549415349
LB1655 n1655 0 0.454545454545455
CV1656 n1656 0 12.6787504285808
LB1656 n1656 0 0.384615384615385
CV1657 n1657 0 14.6373267536658
LB1657 n1657 0 0.333333333333333
CV1658 n1658 0 16.5989084347265
LB1658 n1658 0 0.294117647058823
CV1659 n1659 0 18.5636578020096
LB1659 n1659 0 0.263157894736842
CV1660 n1660 0 20.5316787774293
LB1660 n1660 0 0.238095238095238
CV1661 n1661 0 22.503022339622
LB1661 n1661 0 0.217391304347826
CV1662 n1662 0 24.4776930402472
LB1662 n1662 0 0.2
CV1663 n1663 0 26.4556560061231
LB1663 n1663 0 0.185185185185185
CV1664 n1664 0 28.4368439654652
LB1664 n1664 0 0.172413793103448
CV1665 n1665 0 30.4211639524744
LB1665 n1665 0 0.161290322580645
CV1666 n1666 0 32.4085034562572
LB1666 n1666 0 0.151515151515151
CV1667 n1667 0 34.398735877308
LB1667 n1667 0 0.142857142857143
CV1668 n1668 0 36.3917252327682
LB1668 n1668 0 0.135135135135135
CV1669 n1669 0 38.3873301096261
LB1669 n1669 0 0.128205128205128
CV1670 n1670 0 40.385406904706
LB1670 n1670 0 0.121951219512195
CV1671 n1671 0 42.3858124147369
LB1671 n1671 0 0.116279069767442
CV1672 n1672 0 44.3884058524011
LB1672 n1672 0 0.111111111111111
CV1673 n1673 0 46.3930503682707
LB1673 n1673 0 0.106382978723404
CV1674 n1674 0 48.3996141567079
LB1674 n1674 0 0.102040816326531
CV1675 n1675 0 50.4079712183383
LB1675 n1675 0 0.0980392156862745
CV1676 n1676 0 52.4180018442442
LB1676 n1676 0 0.0943396226415094
CV1677 n1677 0 54.429592878758
LB1677 n1677 0 0.0909090909090909
CV1678 n1678 0 56.4426378094228
LB1678 n1678 0 0.087719298245614
CV1679 n1679 0 58.457036724835
LB1679 n1679 0 0.0847457627118644
CV1680 n1680 0 0.975424212565018
LB1680 n1680 0 5
CV1681 n1681 0 2.92650334691249
LB1681 n1681 0 1.66666666666667
CV1682 n1682 0 4.87826808353674
LB1682 n1682 0 1
CV1683 n1683 0 6.83115417949352
LB1683 n1683 0 0.714285714285714
CV1684 n1684 0 8.78556691157389
LB1684 n1684 0 0.555555555555556
CV1685 n1685 0 10.74187167306
LB1685 n1685 0 0.454545454545455
CV1686 n1686 0 12.7003869653242
LB1686 n1686 0 0.384615384615385
CV1687 n1687 0 14.6613799868033
LB1687 n1687 0 0.333333333333333
CV1688 n1688 0 16.6250647797133
LB1688 n1688 0 0.294117647058823
CV1689 n1689 0 18.591602693816
LB1689 n1689 0 0.263157894736842
CV1690 n1690 0 20.5611047858753
LB1690 n1690 0 0.238095238095238
CV1691 n1691 0 22.5336356986521
LB1691 n1691 0 0.217391304347826
CV1692 n1692 0 24.5092185484474
LB1692 n1692 0 0.2
CV1693 n1693 0 26.4878403821031
LB1693 n1693 0 0.185185185185185
CV1694 n1694 0 28.4694578269133
LB1694 n1694 0 0.172413793103448
CV1695 n1695 0 30.4540026346893
LB1695 n1695 0 0.161290322580645
CV1696 n1696 0 32.441386901742
LB1696 n1696 0 0.151515151515151
CV1697 n1697 0 34.4315078210375
LB1697 n1697 0 0.142857142857143
CV1698 n1698 0 36.4242518861762
LB1698 n1698 0 0.135135135135135
CV1699 n1699 0 38.4194985170614
LB1699 n1699 0 0.128205128205128
CV1700 n1700 0 40.417123114231
LB1700 n1700 0 0.121951219512195
CV1701 n1701 0 42.4169995741859
LB1701 n1701 0 0.116279069767442
CV1702 n1702 0 44.4190023136737
LB1702 n1702 0 0.111111111111111
CV1703 n1703 0 46.4230078589267
LB1703 n1703 0 0.106382978723404
CV1704 n1704 0 48.4288960583323
LB1704 n1704 0 0.102040816326531
CV1705 n1705 0 50.4365509756736
LB1705 n1705 0 0.0980392156862745
CV1706 n1706 0 52.4458615172957
LB1706 n1706 0 0.0943396226415094
CV1707 n1707 0 54.4567218414081
LB1707 n1707 0 0.0909090909090909
CV1708 n1708 0 56.469031591972
LB1708 n1708 0 0.087719298245614
CV1709 n1709 0 58.4826959937863
LB1709 n1709 0 0.0847457627118644
CV1710 n1710 0 0.977142756308733
LB1710 n1710 0 5
CV1711 n1711 0 2.93163141810054
LB1711 n1711 0 1.66666666666667
CV1712 n1712 0 4.88672426418961
LB1712 n1712 0 1
CV1713 n1713 0 6.84280686487398
LB1713 n1713 0 0.714285714285714
CV1714 n1714 0 8.80024006210383
LB1714 n1714 0 0.555555555555556
CV1715 n1715 0 10.7593521542602
LB1715 n1715 0 0.454545454545455
CV1716 n1716 0 12.7204328876484
LB1716 n1716 0 0.384615384615385
CV1717 n1717 0 14.683729437112
LB1717 n1717 0 0.333333333333333
CV1718 n1718 0 16.6494443838759
LB1718 n1718 0 0.294117647058823
CV1719 n1719 0 18.6177355481281
LB1719 n1719 0 0.263157894736842
CV1720 n1720 0 20.5887174215261
LB1720 n1720 0 0.238095238095238
CV1721 n1721 0 22.5624638767805
LB1721 n1721 0 0.217391304347826
CV1722 n1722 0 24.5390118060551
LB1722 n1722 0 0.2
CV1723 n1723 0 26.5183653499907
LB1723 n1723 0 0.185185185185185
CV1724 n1724 0 28.5005004147794
LB1724 n1724 0 0.172413793103448
CV1725 n1725 0 30.4853692254824
LB1725 n1725 0 0.161290322580645
CV1726 n1726 0 32.472904720571
LB1726 n1726 0 0.151515151515151
CV1727 n1727 0 34.4630246484408
LB1727 n1727 0 0.142857142857143
CV1728 n1728 0 36.4556352767627
LB1728 n1728 0 0.135135135135135
CV1729 n1729 0 38.4506346674686
LB1729 n1729 0 0.128205128205128
CV1730 n1730 0 40.4479155030789
LB1730 n1730 0 0.121951219512195
CV1731 n1731 0 42.4473674742961
LB1731 n1731 0 0.116279069767442
CV1732 n1732 0 44.448879255319
LB1732 n1732 0 0.111111111111111
CV1733 n1733 0 46.4523401035052
LB1733 n1733 0 0.106382978723404
CV1734 n1734 0 48.4576411252319
LB1734 n1734 0 0.102040816326531
CV1735 n1735 0 50.4646762513524
LB1735 n1735 0 0.0980392156862745
CV1736 n1736 0 52.473342964644
LB1736 n1736 0 0.0943396226415094
CV1737 n1737 0 54.4835428189869
LB1737 n1737 0 0.0909090909090909
CV1738 n1738 0 56.4951817863936
LB1738 n1738 0 0.087719298245614
CV1739 n1739 0 58.5081704639402
LB1739 n1739 0 0.0847457627118644
CV1740 n1740 0 0.978725365384679
LB1740 n1740 0 5
CV1741 n1741 0 2.93635593443608
LB1741 n1741 0 1.66666666666667
CV1742 n1742 0 4.89452173399861
LB1742 n1742 0 1
CV1743 n1743 0 6.85356554621578
LB1743 n1743 0 0.714285714285714
CV1744 n1744 0 8.81380992109169
LB1744 n1744 0 0.555555555555556
CV1745 n1745 0 10.7755506477963
LB1745 n1745 0 0.454545454545455
CV1746 n1746 0 12.7390516030907
LB1746 n1746 0 0.384615384615385
CV1747 n1747 0 14.7045411358481
LB1747 n1747 0 0.333333333333333
CV1748 n1748 0 16.6722100201552
LB1748 n1748 0 0.294117647058823
CV1749 n1749 0 18.6422108964522
LB1749 n1749 0 0.263157894736842
CV1750 n1750 0 20.6146590314719
LB1750 n1750 0 0.238095238095238
CV1751 n1751 0 22.5896341688391
LB1751 n1751 0 0.217391304347826
CV1752 n1752 0 24.5671832134715
LB1752 n1752 0 0.2
CV1753 n1753 0 26.5473234907503
LB1753 n1753 0 0.185185185185185
CV1754 n1754 0 28.5300463398133
LB1754 n1754 0 0.172413793103448
CV1755 n1755 0 30.5153208323661
LB1755 n1755 0 0.161290322580645
CV1756 n1756 0 32.5030974476084
LB1756 n1756 0 0.151515151515151
CV1757 n1757 0 34.4933115748143
LB1757 n1757 0 0.142857142857143
CV1758 n1758 0 36.4858867538543
LB1758 n1758 0 0.135135135135135
CV1759 n1759 0 38.4807375980051
LB1759 n1759 0 0.128205128205128
CV1760 n1760 0 40.4777723715342
LB1760 n1760 0 0.121951219512195
CV1761 n1761 0 42.4768952164704
LB1761 n1761 0 0.116279069767442
CV1762 n1762 0 44.4780080390578
LB1762 n1762 0 0.111111111111111
CV1763 n1763 0 46.4810120773497
LB1763 n1763 0 0.106382978723404
CV1764 n1764 0 48.485809178149
LB1764 n1764 0 0.102040816326531
CV1765 n1765 0 50.4923028149325
LB1765 n1765 0 0.0980392156862745
CV1766 n1766 0 52.5003988793811
LB1766 n1766 0 0.0943396226415094
CV1767 n1767 0 54.510006278373
LB1767 n1767 0 0.0909090909090909
CV1768 n1768 0 56.5210373664
LB1768 n1768 0 0.087719298245614
CV1769 n1769 0 58.5334082407818
LB1769 n1769 0 0.0847457627118644
CV1770 n1770 0 0.980187674055588
LB1770 n1770 0 5
CV1771 n1771 0 2.94072300582477
LB1771 n1771 0 1.66666666666667
CV1772 n1772 0 4.9017347716074
LB1772 n1772 0 1
CV1773 n1773 0 6.86352905471417
LB1773 n1773 0 0.714285714285714
CV1774 n1774 0 8.82639525535281
LB1774 n1774 0 0.555555555555556
CV1775 n1775 0 10.7906006089519
LB1775 n1775 0 0.454545454545455
CV1776 n1776 0 12.756385764337
LB1776 n1776 0 0.384615384615385
CV1777 n1777 0 14.7239615577352
LB1777 n1777 0 0.333333333333333
CV1778 n1778 0 16.6935070260065
LB1778 n1778 0 0.294117647058823
CV1779 n1779 0 18.6651686173862
LB1779 n1779 0 0.263157894736842
CV1780 n1780 0 20.6390604883835
LB1780 n1780 0 0.238095238095238
CV1781 n1781 0 22.6152657259317
LB1781 n1781 0 0.217391304347826
CV1782 n1782 0 24.5938383056629
LB1782 n1782 0 0.2
CV1783 n1783 0 26.5748055886502
LB1783 n1783 0 0.185185185185185
CV1784 n1784 0 28.5581711665921
LB1784 n1784 0 0.172413793103448
CV1785 n1785 0 30.5439178847262
LB1785 n1785 0 0.161290322580645
CV1786 n1786 0 32.5320108981968
LB1786 n1786 0 0.151515151515151
CV1787 n1787 0 34.5224006471148
LB1787 n1787 0 0.142857142857143
CV1788 n1788 0 36.5150256649589
LB1788 n1788 0 0.135135135135135
CV1789 n1789 0 38.5098151620386
LB1789 n1789 0 0.128205128205128
CV1790 n1790 0 40.5066913491473
LB1790 n1790 0 0.121951219512195
CV1791 n1791 0 42.5055714856713
LB1791 n1791 0 0.116279069767442
CV1792 n1792 0 44.5063696512624
LB1792 n1792 0 0.111111111111111
CV1793 n1793 0 46.5089982510287
LB1793 n1793 0 0.106382978723404
CV1794 n1794 0 48.5133692715944
LB1794 n1794 0 0.102040816326531
CV1795 n1795 0 50.5193953099118
LB1795 n1795 0 0.0980392156862745
CV1796 n1796 0 52.5269903990131
LB1796 n1796 0 0.0943396226415094
CV1797 n1797 0 54.5360706555007
LB1797 n1797 0 0.0909090909090909
CV1798 n1798 0 56.5465547729992
LB1798 n1798 0 0.087719298245614
CV1799 n1799 0 58.5583643844068
LB1799 n1799 0 0.0847457627118644
CV1800 n1800 0 0.981542992087649
LB1800 n1800 0 5
CV1801 n1801 0 2.94477194063292
LB1801 n1801 0 1.66666666666667
CV1802 n1802 0 4.90842687283033
LB1802 n1802 0 1
CV1803 n1803 0 6.87278222025247
LB1803 n1803 0 0.714285714285714
CV1804 n1804 0 8.83809855812924
LB1804 n1804 0 0.555555555555556
CV1805 n1805 0 10.8046179798863
LB1805 n1805 0 0.454545454545455
CV1806 n1806 0 12.7725602947814
LB1806 n1806 0 0.384615384615385
CV1807 n1807 0 14.7421201636743
LB1807 n1807 0 0.333333333333333
CV1808 n1808 0 16.7134652196386
LB1808 n1808 0 0.294117647058823
CV1809 n1809 0 18.6867351557497
LB1809 n1809 0 0.263157894736842
CV1810 n1810 0 20.6620417078385
LB1810 n1810 0 0.238095238095238
CV1811 n1811 0 22.6394694190355
LB1811 n1811 0 0.217391304347826
CV1812 n1812 0 24.619077047028
LB1812 n1812 0 0.2
CV1813 n1813 0 26.6008994635809
LB1813 n1813 0 0.185185185185185
CV1814 n1814 0 28.5849498970238
LB1814 n1814 0 0.172413793103448
CV1815 n1815 0 30.5712223792204
LB1815 n1815 0 0.161290322580645
CV1816 n1816 0 32.5596942758678
LB1816 n1816 0 0.151515151515151
CV1817 n1817 0 34.5503287998663
LB1817 n1817 0 0.142857142857143
CV1818 n1818 0 36.5430774294559
LB1818 n1818 0 0.135135135135135
CV1819 n1819 0 38.5378821739555
LB1819 n1819 0 0.128205128205128
CV1820 n1820 0 40.5346776489984
LB1820 n1820 0 0.121951219512195
CV1821 n1821 0 42.5333929394142
LB1821 n1821 0 0.116279069767442
CV1822 n1822 0 44.5339532411057
LB1822 n1822 0 0.111111111111111
CV1823 n1823 0 46.5362812834503
LB1823 n1823 0 0.106382978723404
CV1824 n1824 0 48.5402985411867
LB1824 n1824 0 0.102040816326531
CV1825 n1825 0 50.5459262498051
LB1825 n1825 0 0.0980392156862745
CV1826 n1826 0 52.5530862415551
LB1826 n1826 0 0.0943396226415094
CV1827 n1827 0 54.5617016207413
LB1827 n1827 0 0.0909090909090909
CV1828 n1828 0 56.5716972973671
LB1828 n1828 0 0.087719298245614
CV1829 n1829 0 58.5830003977363
LB1829 n1829 0 0.0847457627118644
CV1830 n1830 0 0.982802723687058
LB1830 n1830 0 5
CV1831 n1831 0 2.94853646034608
LB1831 n1831 0 1.66666666666667
CV1832 n1832 0 4.91465264071319
LB1832 n1832 0 1
CV1833 n1833 0 6.88139825550039
LB1833 n1833 0 0.714285714285714
CV1834 n1834 0 8.84900870945927
LB1834 n1834 0 0.555555555555556
CV1835 n1835 0 10.8177038995624
LB1835 n1835 0 0.454545454545455
CV1836 n1836 0 12.7876849378726
LB1836 n1836 0 0.384615384615385
CV1837 n1837 0 14.7591316158155
LB1837 n1837 0 0.333333333333333
CV1838 n1838 0 16.7322006557276
LB1838 n1838 0 0.294117647058823
CV1839 n1839 0 18.7070247466165
LB1839 n1839 0 0.263157894736842
CV1840 n1840 0 20.6837123183635
LB1840 n1840 0 0.238095238095238
CV1841 n1841 0 22.6623479750867
LB1841 n1841 0 0.217391304347826
CV1842 n1842 0 24.6429934855165
LB1842 n1842 0 0.2
CV1843 n1843 0 26.6256892160596
LB1843 n1843 0 0.185185185185185
CV1844 n1844 0 28.6104558896629
LB1844 n1844 0 0.172413793103448
CV1845 n1845 0 30.597296558846
LB1845 n1845 0 0.161290322580645
CV1846 n1846 0 32.5861986922105
LB1846 n1846 0 0.151515151515151
CV1847 n1847 0 34.5771362882285
LB1847 n1847 0 0.142857142857143
CV1848 n1848 0 36.5700719462507
LB1848 n1848 0 0.135135135135135
CV1849 n1849 0 38.5649588409309
LB1849 n1849 0 0.128205128205128
CV1850 n1850 0 40.5617425615089
LB1850 n1850 0 0.121951219512195
CV1851 n1851 0 42.5603627909189
LB1851 n1851 0 0.116279069767442
CV1852 n1852 0 44.5607548111077
LB1852 n1852 0 0.111111111111111
CV1853 n1853 0 46.5628508301571
LB1853 n1853 0 0.106382978723404
CV1854 n1854 0 48.5665811338878
LB1854 n1854 0 0.102040816326531
CV1855 n1855 0 50.5718750697814
LB1855 n1855 0 0.0980392156862745
CV1856 n1856 0 52.578661874558
LB1856 n1856 0 0.0943396226415094
CV1857 n1857 0 54.5868713588955
LB1857 n1857 0 0.0909090909090909
CV1858 n1858 0 56.5964344638356
LB1858 n1858 0 0.087719298245614
CV1859 n1859 0 58.6072837036689
LB1859 n1859 0 0.0847457627118644
CV1860 n1860 0 0.983976698550676
LB1860 n1860 0 5
CV1861 n1861 0 2.95204566201592
LB1861 n1861 0 1.66666666666667
CV1862 n1862 0 4.92045929137972
LB1862 n1862 0 1
CV1863 n1863 0 6.8894406714359
LB1863 n1863 0 0.714285714285714
CV1864 n1864 0 8.85920313876667
LB1864 n1864 0 0.555555555555556
CV1865 n1865 0 10.8299469410443
LB1865 n1865 0 0.454545454545455
CV1866 n1866 0 12.801856405331
LB1866 n1866 0 0.384615384615385
CV1867 n1867 0 14.7750976964301
LB1867 n1867 0 0.333333333333333
CV1868 n1868 0 16.7498172082009
LB1868 n1868 0 0.294117647058823
CV1869 n1869 0 18.7261405933556
LB1869 n1869 0 0.263157894736842
CV1870 n1870 0 20.7041724037739
LB1870 n1870 0 0.238095238095238
CV1871 n1871 0 22.6839962861308
LB1871 n1871 0 0.217391304347826
CV1872 n1872 0 24.6656756579248
LB1872 n1872 0 0.2
CV1873 n1873 0 26.6492547771351
LB1873 n1873 0 0.185185185185185
CV1874 n1874 0 28.6347601142159
LB1874 n1874 0 0.172413793103448
CV1875 n1875 0 30.6222019368522
LB1875 n1875 0 0.161290322580645
CV1876 n1876 0 32.6115760244213
LB1876 n1876 0 0.151515151515151
CV1877 n1877 0 34.6028654389207
LB1877 n1877 0 0.142857142857143
CV1878 n1878 0 36.5960422908003
LB1878 n1878 0 0.135135135135135
CV1879 n1879 0 38.591069450459
LB1879 n1879 0 0.128205128205128
CV1880 n1880 0 40.5879021681888
LB1880 n1880 0 0.121951219512195
CV1881 n1881 0 42.5864895764048
LB1881 n1881 0 0.116279069767442
CV1882 n1882 0 44.5867760576752
LB1882 n1882 0 0.111111111111111
CV1883 n1883 0 46.5887024701739
LB1883 n1883 0 0.106382978723404
CV1884 n1884 0 48.5922072286774
LB1884 n1884 0 0.102040816326531
CV1885 n1885 0 50.5972272442198
LB1885 n1885 0 0.0980392156862745
CV1886 n1886 0 52.6036987291404
LB1886 n1886 0 0.0943396226415094
CV1887 n1887 0 54.611557876724
LB1887 n1887 0 0.0909090909090909
CV1888 n1888 0 56.6207414261291
LB1888 n1888 0 0.087719298245614
CV1889 n1889 0 58.6311871240363
LB1889 n1889 0 0.0847457627118644
CV1890 n1890 0 0.985073435901757
LB1890 n1890 0 5
CV1891 n1891 0 2.95532478771761
LB1891 n1891 0 1.66666666666667
CV1892 n1892 0 4.92588786377051
LB1892 n1892 0 1
CV1893 n1893 0 6.89696482766358
LB1893 n1893 0 0.714285714285714
CV1894 n1894 0 8.86874959316585
LB1894 n1894 0 0.555555555555556
CV1895 n1895 0 10.8414249657908
LB1895 n1895 0 0.454545454545455
CV1896 n1896 0 12.8151601892738
LB1896 n1896 0 0.384615384615385
CV1897 n1897 0 14.7901089647906
LB1897 n1897 0 0.333333333333333
CV1898 n1898 0 16.7664079819274
LB1898 n1898 0 0.294117647058823
CV1899 n1899 0 18.7441759716749
LB1899 n1899 0 0.263157894736842
CV1900 n1900 0 20.7235132654166
LB1900 n1900 0 0.238095238095238
CV1901 n1901 0 22.7045018218086
LB1901 n1901 0 0.217391304347826
CV1902 n1902 0 24.6872056667239
LB1902 n1902 0 0.2
CV1903 n1903 0 26.6716716804672
LB1903 n1903 0 0.185185185185185
CV1904 n1904 0 28.6579306610776
LB1904 n1904 0 0.172413793103448
CV1905 n1905 0 30.6459985920765
LB1905 n1905 0 0.161290322580645
CV1906 n1906 0 32.6358780465353
LB1906 n1906 0 0.151515151515151
CV1907 n1907 0 34.6275596657801
LB1907 n1907 0 0.142857142857143
CV1908 n1908 0 36.6210236593514
LB1908 n1908 0 0.135135135135135
CV1909 n1909 0 38.6162412820522
LB1909 n1909 0 0.128205128205128
CV1910 n1910 0 40.613176253279
LB1910 n1910 0 0.121951219512195
CV1911 n1911 0 42.6117860927339
LB1911 n1911 0 0.116279069767442
CV1912 n1912 0 44.6120233546841
LB1912 n1912 0 0.111111111111111
CV1913 n1913 0 46.6138367499166
LB1913 n1913 0 0.106382978723404
CV1914 n1914 0 48.6171721503515
LB1914 n1914 0 0.102040816326531
CV1915 n1915 0 50.6219734759186
LB1915 n1915 0 0.0980392156862745
CV1916 n1916 0 52.6281834668542
LB1916 n1916 0 0.0943396226415094
CV1917 n1917 0 54.6357443471554
LB1917 n1917 0 0.0909090909090909
CV1918 n1918 0 56.6445983866746
LB1918 n1918 0 0.087719298245614
CV1919 n1919 0 58.6546883703981
LB1919 n1919 0 0.0847457627118644
CV1920 n1920 0 0.986100356883512
LB1920 n1920 0 5
CV1921 n1921 0 2.95839584482796
LB1921 n1921 0 1.66666666666667
CV1922 n1922 0 4.93097419904232
LB1922 n1922 0 1
CV1923 n1923 0 6.904019195824
LB1923 n1923 0 0.714285714285714
CV1924 n1924 0 8.87770759161338
LB1924 n1924 0 0.555555555555556
CV1925 n1925 0 10.8522066667316
LB1925 n1925 0 0.454545454545455
CV1926 n1926 0 12.8276720934954
LB1926 n1926 0 0.384615384615385
CV1927 n1927 0 14.8042461854983
LB1927 n1927 0 0.333333333333333
CV1928 n1928 0 16.782056562892
LB1928 n1928 0 0.294117647058823
CV1929 n1929 0 18.7612152462882
LB1929 n1929 0 0.263157894736842
CV1930 n1930 0 20.74181817118
LB1930 n1930 0 0.238095238095238
CV1931 n1931 0 22.7239450969287
LB1931 n1931 0 0.217391304347826
CV1932 n1932 0 24.7076598703008
LB1932 n1932 0 0.2
CV1933 n1933 0 26.6930109937169
LB1933 n1933 0 0.185185185185185
CV1934 n1934 0 28.6800324427763
LB1934 n1934 0 0.172413793103448
CV1935 n1935 0 30.6687446758896
LB1935 n1935 0 0.161290322580645
CV1936 n1936 0 32.6591557803718
LB1936 n1936 0 0.151515151515151
CV1937 n1937 0 34.6512627033892
LB1937 n1937 0 0.142857142857143
CV1938 n1938 0 36.6450525219311
LB1938 n1938 0 0.135135135135135
CV1939 n1939 0 38.6405037127773
LB1939 n1939 0 0.128205128205128
CV1940 n1940 0 40.6375873906265
LB1940 n1940 0 0.121951219512195
CV1941 n1941 0 42.6362684896416
LB1941 n1941 0 0.116279069767442
CV1942 n1942 0 44.6365068702921
LB1942 n1942 0 0.111111111111111
CV1943 n1943 0 46.6382583392959
LB1943 n1943 0 0.106382978723404
CV1944 n1944 0 48.6414755755454
LB1944 n1944 0 0.102040816326531
CV1945 n1945 0 50.6461089591154
LB1945 n1945 0 0.0980392156862745
CV1946 n1946 0 52.6521073037957
LB1946 n1946 0 0.0943396226415094
CV1947 n1947 0 54.6594184961522
LB1947 n1947 0 0.0909090909090909
CV1948 n1948 0 56.6679900459739
LB1948 n1948 0 0.087719298245614
CV1949 n1949 0 58.6777695542151
LB1949 n1949 0 0.0847457627118644
CS0 n0 n1 1.25
CS1 n0 n30 0.625
CS2 n0 0 0.625
CS3 n1 n2 2.5
CS4 n1 n31 1.875
CS5 n1 0 1.875
CS6 n2 n3 3.75
CS7 n2 n32 3.125
CS8 n2 0 3.125
CS9 n3 n4 5
CS10 n3 n33 4.375
CS11 n3 0 4.375
CS12 n4 n5 6.25
CS13 n4 n34 5.625
CS14 n4 0 5.625
CS15 n5 n6 7.5
CS16 n5 n35 6.875
CS17 n5 0 6.875
CS18 n6 n7 8.75
CS19 n6 n36 8.125
CS20 n6 0 8.125
CS21 n7 n8 10
CS22 n7 n37 9.375
CS23 n7 0 9.375
CS24 n8 n9 11.25
CS25 n8 n38 10.625
CS26 n8 0 10.625
CS27 n9 n10 12.5
CS28 n9 n39 11.875
CS29 n9 0 11.875
CS30 n10 n11 13.75
CS31 n10 n40 13.125
CS32 n10 0 13.125
CS33 n11 n12 15
CS34 n11 n41 14.375
CS35 n11 0 14.375
CS36 n12 n13 16.25
CS37 n12 n42 15.625
CS38 n12 0 15.625
CS39 n13 n14 17.5
CS40 n13 n43 16.875
CS41 n13 0 16.875
CS42 n14 n15 18.75
CS43 n14 n44 18.125
CS44 n14 0 18.125
CS45 n15 n16 20
CS46 n15 n45 19.375
CS47 n15 0 19.375
CS48 n16 n17 21.25
CS49 n16 n46 20.625
CS50 n16 0 20.625
CS51 n17 n18 22.5
CS52 n17 n47 21.875
CS53 n17 0 21.875
CS54 n18 n19 23.75
CS55 n18 n48 23.125
CS56 n18 0 23.125
CS57 n19 n20 25
CS58 n19 n49 24.375
CS59 n19 0 24.375
CS60 n20 n21 26.25
CS61 n20 n50 25.625
CS62 n20 0 25.625
CS63 n21 n22 27.5
CS64 n21 n51 26.875
CS65 n21 0 26.875
CS66 n22 n23 28.75
CS67 n22 n52 28.125
CS68 n22 0 28.125
CS69 n23 n24 30
CS70 n23 n53 29.375
CS71 n23 0 29.375
CS72 n24 n25 31.25
CS73 n24 n54 30.625
CS74 n24 0 30.625
CS75 n25 n26 32.5
CS76 n25 n55 31.875
CS77 n25 0 31.875
CS78 n26 n27 33.75
CS79 n26 n56 33.125
CS80 n26 0 33.125
CS81 n27 n28 35
CS82 n27 n57 34.375
CS83 n27 0 34.375
CS84 n28 n29 36.25
CS85 n28 n58 35.625
CS86 n28 0 35.625
CS87 n29 0 37.5
CS88 n29 n59 36.875
CS89 n29 0 36.875
CS90 n30 n31 1.25
CS91 n30 n60 0.625
CS92 n31 n32 2.5
CS93 n31 n61 1.875
CS94 n32 n33 3.75
CS95 n32 n62 3.125
CS96 n33 n34 5
CS97 n33 n63 4.375
CS98 n34 n35 6.25
CS99 n34 n64 5.625
CS100 n35 n36 7.5
CS101 n35 n65 6.875
CS102 n36 n37 8.75
CS103 n36 n66 8.125
CS104 n37 n38 10
CS105 n37 n67 9.375
CS106 n38 n39 11.25
CS107 n38 n68 10.625
CS108 n39 n40 12.5
CS109 n39 n69 11.875
CS110 n40 n41 13.75
CS111 n40 n70 13.125
CS112 n41 n42 15
CS113 n41 n71 14.375
CS114 n42 n43 16.25
CS115 n42 n72 15.625
CS116 n43 n44 17.5
CS117 n43 n73 16.875
CS118 n44 n45 18.75
CS119 n44 n74 18.125
CS120 n45 n46 20
CS121 n45 n75 19.375
CS122 n46 n47 21.25
CS123 n46 n76 20.625
CS124 n47 n48 22.5
CS125 n47 n77 21.875
CS126 n48 n49 23.75
CS127 n48 n78 23.125
CS128 n49 n50 25
CS129 n49 n79 24.375
CS130 n50 n51 26.25
CS131 n50 n80 25.625
CS132 n51 n52 27.5
CS133 n51 n81 26.875
CS134 n52 n53 28.75
CS135 n52 n82 28.125
CS136 n53 n54 30
CS137 n53 n83 29.375
CS138 n54 n55 31.25
CS139 n54 n84 30.625
CS140 n55 n56 32.5
CS141 n55 n85 31.875
CS142 n56 n57 33.75
CS143 n56 n86 33.125
CS144 n57 n58 35
CS145 n57 n87 34.375
CS146 n58 n59 36.25
CS147 n58 n88 35.625
CS148 n59 0 37.5
CS149 n59 n89 36.875
CS150 n60 n61 1.25
CS151 n60 n90 0.625
CS152 n61 n62 2.5
CS153 n61 n91 1.875
CS154 n62 n63 3.75
CS155 n62 n92 3.125
CS156 n63 n64 5
CS157 n63 n93 4.375
CS158 n64 n65 6.25
CS159 n64 n94 5.625
CS160 n65 n66 7.5
CS161 n65 n95 6.875
CS162 n66 n67 8.75
CS163 n66 n96 8.125
CS164 n67 n68 10
CS165 n67 n97 9.375
CS166 n68 n69 11.25
CS167 n68 n98 10.625
CS168 n69 n70 12.5
CS169 n69 n99 11.875
CS170 n70 n71 13.75
CS171 n70 n100 13.125
CS172 n71 n72 15
CS173 n71 n101 14.375
CS174 n72 n73 16.25
CS175 n72 n102 15.625
CS176 n73 n74 17.5
CS177 n73 n103 16.875
CS178 n74 n75 18.75
CS179 n74 n104 18.125
CS180 n75 n76 20
CS181 n75 n105 19.375
CS182 n76 n77 21.25
CS183 n76 n106 20.625
CS184 n77 n78 22.5
CS185 n77 n107 21.875
CS186 n78 n79 23.75
CS187 n78 n108 23.125
CS188 n79 n80 25
CS189 n79 n109 24.375
CS190 n80 n81 26.25
CS191 n80 n110 25.625
CS192 n81 n82 27.5
CS193 n81 n111 26.875
CS194 n82 n83 28.75
CS195 n82 n112 28.125
CS196 n83 n84 30
CS197 n83 n113 29.375
CS198 n84 n85 31.25
CS199 n84 n114 30.625
CS200 n85 n86 32.5
CS201 n85 n115 31.875
CS202 n86 n87 33.75
CS203 n86 n116 33.125
CS204 n87 n88 35
CS205 n87 n117 34.375
CS206 n88 n89 36.25
CS207 n88 n118 35.625
CS208 n89 0 37.5
CS209 n89 n119 36.875
CS210 n90 n91 1.25
CS211 n90 n120 0.625
CS212 n91 n92 2.5
CS213 n91 n121 1.875
CS214 n92 n93 3.75
CS215 n92 n122 3.125
CS216 n93 n94 5
CS217 n93 n123 4.375
CS218 n94 n95 6.25
CS219 n94 n124 5.625
CS220 n95 n96 7.5
CS221 n95 n125 6.875
CS222 n96 n97 8.75
CS223 n96 n126 8.125
CS224 n97 n98 10
CS225 n97 n127 9.375
CS226 n98 n99 11.25
CS227 n98 n128 10.625
CS228 n99 n100 12.5
CS229 n99 n129 11.875
CS230 n100 n101 13.75
CS231 n100 n130 13.125
CS232 n101 n102 15
CS233 n101 n131 14.375
CS234 n102 n103 16.25
CS235 n102 n132 15.625
CS236 n103 n104 17.5
CS237 n103 n133 16.875
CS238 n104 n105 18.75
CS239 n104 n134 18.125
CS240 n105 n106 20
CS241 n105 n135 19.375
CS242 n106 n107 21.25
CS243 n106 n136 20.625
CS244 n107 n108 22.5
CS245 n107 n137 21.875
CS246 n108 n109 23.75
CS247 n108 n138 23.125
CS248 n109 n110 25
CS249 n109 n139 24.375
CS250 n110 n111 26.25
CS251 n110 n140 25.625
CS252 n111 n112 27.5
CS253 n111 n141 26.875
CS254 n112 n113 28.75
CS255 n112 n142 28.125
CS256 n113 n114 30
CS257 n113 n143 29.375
CS258 n114 n115 31.25
CS259 n114 n144 30.625
CS260 n115 n116 32.5
CS261 n115 n145 31.875
CS262 n116 n117 33.75
CS263 n116 n146 33.125
CS264 n117 n118 35
CS265 n117 n147 34.375
CS266 n118 n119 36.25
CS267 n118 n148 35.625
CS268 n119 0 37.5
CS269 n119 n149 36.875
CS270 n120 n121 1.25
CS271 n120 n150 0.625
CS272 n121 n122 2.5
CS273 n121 n151 1.875
CS274 n122 n123 3.75
CS275 n122 n152 3.125
CS276 n123 n124 5
CS277 n123 n153 4.375
CS278 n124 n125 6.25
CS279 n124 n154 5.625
CS280 n125 n126 7.5
CS281 n125 n155 6.875
CS282 n126 n127 8.75
CS283 n126 n156 8.125
CS284 n127 n128 10
CS285 n127 n157 9.375
CS286 n128 n129 11.25
CS287 n128 n158 10.625
CS288 n129 n130 12.5
CS289 n129 n159 11.875
CS290 n130 n131 13.75
CS291 n130 n160 13.125
CS292 n131 n132 15
CS293 n131 n161 14.375
CS294 n132 n133 16.25
CS295 n132 n162 15.625
CS296 n133 n134 17.5
CS297 n133 n163 16.875
CS298 n134 n135 18.75
CS299 n134 n164 18.125
CS300 n135 n136 20
CS301 n135 n165 19.375
CS302 n136 n137 21.25
CS303 n136 n166 20.625
CS304 n137 n138 22.5
CS305 n137 n167 21.875
CS306 n138 n139 23.75
CS307 n138 n168 23.125
CS308 n139 n140 25
CS309 n139 n169 24.375
CS310 n140 n141 26.25
CS311 n140 n170 25.625
CS312 n141 n142 27.5
CS313 n141 n171 26.875
CS314 n142 n143 28.75
CS315 n142 n172 28.125
CS316 n143 n144 30
CS317 n143 n173 29.375
CS318 n144 n145 31.25
CS319 n144 n174 30.625
CS320 n145 n146 32.5
CS321 n145 n175 31.875
CS322 n146 n147 33.75
CS323 n146 n176 33.125
CS324 n147 n148 35
CS325 n147 n177 34.375
CS326 n148 n149 36.25
CS327 n148 n178 35.625
CS328 n149 0 37.5
CS329 n149 n179 36.875
CS330 n150 n151 1.25
CS331 n150 n180 0.625
CS332 n151 n152 2.5
CS333 n151 n181 1.875
CS334 n152 n153 3.75
CS335 n152 n182 3.125
CS336 n153 n154 5
CS337 n153 n183 4.375
CS338 n154 n155 6.25
CS339 n154 n184 5.625
CS340 n155 n156 7.5
CS341 n155 n185 6.875
CS342 n156 n157 8.75
CS343 n156 n186 8.125
CS344 n157 n158 10
CS345 n157 n187 9.375
CS346 n158 n159 11.25
CS347 n158 n188 10.625
CS348 n159 n160 12.5
CS349 n159 n189 11.875
CS350 n160 n161 13.75
CS351 n160 n190 13.125
CS352 n161 n162 15
CS353 n161 n191 14.375
CS354 n162 n163 16.25
CS355 n162 n192 15.625
CS356 n163 n164 17.5
CS357 n163 n193 16.875
CS358 n164 n165 18.75
CS359 n164 n194 18.125
CS360 n165 n166 20
CS361 n165 n195 19.375
CS362 n166 n167 21.25
CS363 n166 n196 20.625
CS364 n167 n168 22.5
CS365 n167 n197 21.875
CS366 n168 n169 23.75
CS367 n168 n198 23.125
CS368 n169 n170 25
CS369 n169 n199 24.375
CS370 n170 n171 26.25
CS371 n170 n200 25.625
CS372 n171 n172 27.5
CS373 n171 n201 26.875
CS374 n172 n173 28.75
CS375 n172 n202 28.125
CS376 n173 n174 30
CS377 n173 n203 29.375
CS378 n174 n175 31.25
CS379 n174 n204 30.625
CS380 n175 n176 32.5
CS381 n175 n205 31.875
CS382 n176 n177 33.75
CS383 n176 n206 33.125
CS384 n177 n178 35
CS385 n177 n207 34.375
CS386 n178 n179 36.25
CS387 n178 n208 35.625
CS388 n179 0 37.5
CS389 n179 n209 36.875
CS390 n180 n181 1.25
CS391 n180 n210 0.625
CS392 n181 n182 2.5
CS393 n181 n211 1.875
CS394 n182 n183 3.75
CS395 n182 n212 3.125
CS396 n183 n184 5
CS397 n183 n213 4.375
CS398 n184 n185 6.25
CS399 n184 n214 5.625
CS400 n185 n186 7.5
CS401 n185 n215 6.875
CS402 n186 n187 8.75
CS403 n186 n216 8.125
CS404 n187 n188 10
CS405 n187 n217 9.375
CS406 n188 n189 11.25
CS407 n188 n218 10.625
CS408 n189 n190 12.5
CS409 n189 n219 11.875
CS410 n190 n191 13.75
CS411 n190 n220 13.125
CS412 n191 n192 15
CS413 n191 n221 14.375
CS414 n192 n193 16.25
CS415 n192 n222 15.625
CS416 n193 n194 17.5
CS417 n193 n223 16.875
CS418 n194 n195 18.75
CS419 n194 n224 18.125
CS420 n195 n196 20
CS421 n195 n225 19.375
CS422 n196 n197 21.25
CS423 n196 n226 20.625
CS424 n197 n198 22.5
CS425 n197 n227 21.875
CS426 n198 n199 23.75
CS427 n198 n228 23.125
CS428 n199 n200 25
CS429 n199 n229 24.375
CS430 n200 n201 26.25
CS431 n200 n230 25.625
CS432 n201 n202 27.5
CS433 n201 n231 26.875
CS434 n202 n203 28.75
CS435 n202 n232 28.125
CS436 n203 n204 30
CS437 n203 n233 29.375
CS438 n204 n205 31.25
CS439 n204 n234 30.625
CS440 n205 n206 32.5
CS441 n205 n235 31.875
CS442 n206 n207 33.75
CS443 n206 n236 33.125
CS444 n207 n208 35
CS445 n207 n237 34.375
CS446 n208 n209 36.25
CS447 n208 n238 35.625
CS448 n209 0 37.5
CS449 n209 n239 36.875
CS450 n210 n211 1.25
CS451 n210 n240 0.625
CS452 n211 n212 2.5
CS453 n211 n241 1.875
CS454 n212 n213 3.75
CS455 n212 n242 3.125
CS456 n213 n214 5
CS457 n213 n243 4.375
CS458 n214 n215 6.25
CS459 n214 n244 5.625
CS460 n215 n216 7.5
CS461 n215 n245 6.875
CS462 n216 n217 8.75
CS463 n216 n246 8.125
CS464 n217 n218 10
CS465 n217 n247 9.375
CS466 n218 n219 11.25
CS467 n218 n248 10.625
CS468 n219 n220 12.5
CS469 n219 n249 11.875
CS470 n220 n221 13.75
CS471 n220 n250 13.125
CS472 n221 n222 15
CS473 n221 n251 14.375
CS474 n222 n223 16.25
CS475 n222 n252 15.625
CS476 n223 n224 17.5
CS477 n223 n253 16.875
CS478 n224 n225 18.75
CS479 n224 n254 18.125
CS480 n225 n226 20
CS481 n225 n255 19.375
CS482 n226 n227 21.25
CS483 n226 n256 20.625
CS484 n227 n228 22.5
CS485 n227 n257 21.875
CS486 n228 n229 23.75
CS487 n228 n258 23.125
CS488 n229 n230 25
CS489 n229 n259 24.375
CS490 n230 n231 26.25
CS491 n230 n260 25.625
CS492 n231 n232 27.5
CS493 n231 n261 26.875
CS494 n232 n233 28.75
CS495 n232 n262 28.125
CS496 n233 n234 30
CS497 n233 n263 29.375
CS498 n234 n235 31.25
CS499 n234 n264 30.625
CS500 n235 n236 32.5
CS501 n235 n265 31.875
CS502 n236 n237 33.75
CS503 n236 n266 33.125
CS504 n237 n238 35
CS505 n237 n267 34.375
CS506 n238 n239 36.25
CS507 n238 n268 35.625
CS508 n239 0 37.5
CS509 n239 n269 36.875
CS510 n240 n241 1.25
CS511 n240 n270 0.625
CS512 n241 n242 2.5
CS513 n241 n271 1.875
CS514 n242 n243 3.75
CS515 n242 n272 3.125
CS516 n243 n244 5
CS517 n243 n273 4.375
CS518 n244 n245 6.25
CS519 n244 n274 5.625
CS520 n245 n246 7.5
CS521 n245 n275 6.875
CS522 n246 n247 8.75
CS523 n246 n276 8.125
CS524 n247 n248 10
CS525 n247 n277 9.375
CS526 n248 n249 11.25
CS527 n248 n278 10.625
CS528 n249 n250 12.5
CS529 n249 n279 11.875
CS530 n250 n251 13.75
CS531 n250 n280 13.125
CS532 n251 n252 15
CS533 n251 n281 14.375
CS534 n252 n253 16.25
CS535 n252 n282 15.625
CS536 n253 n254 17.5
CS537 n253 n283 16.875
CS538 n254 n255 18.75
CS539 n254 n284 18.125
CS540 n255 n256 20
CS541 n255 n285 19.375
CS542 n256 n257 21.25
CS543 n256 n286 20.625
CS544 n257 n258 22.5
CS545 n257 n287 21.875
CS546 n258 n259 23.75
CS547 n258 n288 23.125
CS548 n259 n260 25
CS549 n259 n289 24.375
CS550 n260 n261 26.25
CS551 n260 n290 25.625
CS552 n261 n262 27.5
CS553 n261 n291 26.875
CS554 n262 n263 28.75
CS555 n262 n292 28.125
CS556 n263 n264 30
CS557 n263 n293 29.375
CS558 n264 n265 31.25
CS559 n264 n294 30.625
CS560 n265 n266 32.5
CS561 n265 n295 31.875
CS562 n266 n267 33.75
CS563 n266 n296 33.125
CS564 n267 n268 35
CS565 n267 n297 34.375
CS566 n268 n269 36.25
CS567 n268 n298 35.625
CS568 n269 0 37.5
CS569 n269 n299 36.875
CS570 n270 n271 1.25
CS571 n270 n300 0.625
CS572 n271 n272 2.5
CS573 n271 n301 1.875
CS574 n272 n273 3.75
CS575 n272 n302 3.125
CS576 n273 n274 5
CS577 n273 n303 4.375
CS578 n274 n275 6.25
CS579 n274 n304 5.625
CS580 n275 n276 7.5
CS581 n275 n305 6.875
CS582 n276 n277 8.75
CS583 n276 n306 8.125
CS584 n277 n278 10
CS585 n277 n307 9.375
CS586 n278 n279 11.25
CS587 n278 n308 10.625
CS588 n279 n280 12.5
CS589 n279 n309 11.875
CS590 n280 n281 13.75
CS591 n280 n310 13.125
CS592 n281 n282 15
CS593 n281 n311 14.375
CS594 n282 n283 16.25
CS595 n282 n312 15.625
CS596 n283 n284 17.5
CS597 n283 n313 16.875
CS598 n284 n285 18.75
CS599 n284 n314 18.125
CS600 n285 n286 20
CS601 n285 n315 19.375
CS602 n286 n287 21.25
CS603 n286 n316 20.625
CS604 n287 n288 22.5
CS605 n287 n317 21.875
CS606 n288 n289 23.75
CS607 n288 n318 23.125
CS608 n289 n290 25
CS609 n289 n319 24.375
CS610 n290 n291 26.25
CS611 n290 n320 25.625
CS612 n291 n292 27.5
CS613 n291 n321 26.875
CS614 n292 n293 28.75
CS615 n292 n322 28.125
CS616 n293 n294 30
CS617 n293 n323 29.375
CS618 n294 n295 31.25
CS619 n294 n324 30.625
CS620 n295 n296 32.5
CS621 n295 n325 31.875
CS622 n296 n297 33.75
CS623 n296 n326 33.125
CS624 n297 n298 35
CS625 n297 n327 34.375
CS626 n298 n299 36.25
CS627 n298 n328 35.625
CS628 n299 0 37.5
CS629 n299 n329 36.875
CS630 n300 n301 1.25
CS631 n300 n330 0.625
CS632 n301 n302 2.5
CS633 n301 n331 1.875
CS634 n302 n303 3.75
CS635 n302 n332 3.125
CS636 n303 n304 5
CS637 n303 n333 4.375
CS638 n304 n305 6.25
CS639 n304 n334 5.625
CS640 n305 n306 7.5
CS641 n305 n335 6.875
CS642 n306 n307 8.75
CS643 n306 n336 8.125
CS644 n307 n308 10
CS645 n307 n337 9.375
CS646 n308 n309 11.25
CS647 n308 n338 10.625
CS648 n309 n310 12.5
CS649 n309 n339 11.875
CS650 n310 n311 13.75
CS651 n310 n340 13.125
CS652 n311 n312 15
CS653 n311 n341 14.375
CS654 n312 n313 16.25
CS655 n312 n342 15.625
CS656 n313 n314 17.5
CS657 n313 n343 16.875
CS658 n314 n315 18.75
CS659 n314 n344 18.125
CS660 n315 n316 20
CS661 n315 n345 19.375
CS662 n316 n317 21.25
CS663 n316 n346 20.625
CS664 n317 n318 22.5
CS665 n317 n347 21.875
CS666 n318 n319 23.75
CS667 n318 n348 23.125
CS668 n319 n320 25
CS669 n319 n349 24.375
CS670 n320 n321 26.25
CS671 n320 n350 25.625
CS672 n321 n322 27.5
CS673 n321 n351 26.875
CS674 n322 n323 28.75
CS675 n322 n352 28.125
CS676 n323 n324 30
CS677 n323 n353 29.375
CS678 n324 n325 31.25
CS679 n324 n354 30.625
CS680 n325 n326 32.5
CS681 n325 n355 31.875
CS682 n326 n327 33.75
CS683 n326 n356 33.125
CS684 n327 n328 35
CS685 n327 n357 34.375
CS686 n328 n329 36.25
CS687 n328 n358 35.625
CS688 n329 0 37.5
CS689 n329 n359 36.875
CS690 n330 n331 1.25
CS691 n330 n360 0.625
CS692 n331 n332 2.5
CS693 n331 n361 1.875
CS694 n332 n333 3.75
CS695 n332 n362 3.125
CS696 n333 n334 5
CS697 n333 n363 4.375
CS698 n334 n335 6.25
CS699 n334 n364 5.625
CS700 n335 n336 7.5
CS701 n335 n365 6.875
CS702 n336 n337 8.75
CS703 n336 n366 8.125
CS704 n337 n338 10
CS705 n337 n367 9.375
CS706 n338 n339 11.25
CS707 n338 n368 10.625
CS708 n339 n340 12.5
CS709 n339 n369 11.875
CS710 n340 n341 13.75
CS711 n340 n370 13.125
CS712 n341 n342 15
CS713 n341 n371 14.375
CS714 n342 n343 16.25
CS715 n342 n372 15.625
CS716 n343 n344 17.5
CS717 n343 n373 16.875
CS718 n344 n345 18.75
CS719 n344 n374 18.125
CS720 n345 n346 20
CS721 n345 n375 19.375
CS722 n346 n347 21.25
CS723 n346 n376 20.625
CS724 n347 n348 22.5
CS725 n347 n377 21.875
CS726 n348 n349 23.75
CS727 n348 n378 23.125
CS728 n349 n350 25
CS729 n349 n379 24.375
CS730 n350 n351 26.25
CS731 n350 n380 25.625
CS732 n351 n352 27.5
CS733 n351 n381 26.875
CS734 n352 n353 28.75
CS735 n352 n382 28.125
CS736 n353 n354 30
CS737 n353 n383 29.375
CS738 n354 n355 31.25
CS739 n354 n384 30.625
CS740 n355 n356 32.5
CS741 n355 n385 31.875
CS742 n356 n357 33.75
CS743 n356 n386 33.125
CS744 n357 n358 35
CS745 n357 n387 34.375
CS746 n358 n359 36.25
CS747 n358 n388 35.625
CS748 n359 0 37.5
CS749 n359 n389 36.875
CS750 n360 n361 1.25
CS751 n360 n390 0.625
CS752 n361 n362 2.5
CS753 n361 n391 1.875
CS754 n362 n363 3.75
CS755 n362 n392 3.125
CS756 n363 n364 5
CS757 n363 n393 4.375
CS758 n364 n365 6.25
CS759 n364 n394 5.625
CS760 n365 n366 7.5
CS761 n365 n395 6.875
CS762 n366 n367 8.75
CS763 n366 n396 8.125
CS764 n367 n368 10
CS765 n367 n397 9.375
CS766 n368 n369 11.25
CS767 n368 n398 10.625
CS768 n369 n370 12.5
CS769 n369 n399 11.875
CS770 n370 n371 13.75
CS771 n370 n400 13.125
CS772 n371 n372 15
CS773 n371 n401 14.375
CS774 n372 n373 16.25
CS775 n372 n402 15.625
CS776 n373 n374 17.5
CS777 n373 n403 16.875
CS778 n374 n375 18.75
CS779 n374 n404 18.125
CS780 n375 n376 20
CS781 n375 n405 19.375
CS782 n376 n377 21.25
CS783 n376 n406 20.625
CS784 n377 n378 22.5
CS785 n377 n407 21.875
CS786 n378 n379 23.75
CS787 n378 n408 23.125
CS788 n379 n380 25
CS789 n379 n409 24.375
CS790 n380 n381 26.25
CS791 n380 n410 25.625
CS792 n381 n382 27.5
CS793 n381 n411 26.875
CS794 n382 n383 28.75
CS795 n382 n412 28.125
CS796 n383 n384 30
CS797 n383 n413 29.375
CS798 n384 n385 31.25
CS799 n384 n414 30.625
CS800 n385 n386 32.5
CS801 n385 n415 31.875
CS802 n386 n387 33.75
CS803 n386 n416 33.125
CS804 n387 n388 35
CS805 n387 n417 34.375
CS806 n388 n389 36.25
CS807 n388 n418 35.625
CS808 n389 0 37.5
CS809 n389 n419 36.875
CS810 n390 n391 1.25
CS811 n390 n420 0.625
CS812 n391 n392 2.5
CS813 n391 n421 1.875
CS814 n392 n393 3.75
CS815 n392 n422 3.125
CS816 n393 n394 5
CS817 n393 n423 4.375
CS818 n394 n395 6.25
CS819 n394 n424 5.625
CS820 n395 n396 7.5
CS821 n395 n425 6.875
CS822 n396 n397 8.75
CS823 n396 n426 8.125
CS824 n397 n398 10
CS825 n397 n427 9.375
CS826 n398 n399 11.25
CS827 n398 n428 10.625
CS828 n399 n400 12.5
CS829 n399 n429 11.875
CS830 n400 n401 13.75
CS831 n400 n430 13.125
CS832 n401 n402 15
CS833 n401 n431 14.375
CS834 n402 n403 16.25
CS835 n402 n432 15.625
CS836 n403 n404 17.5
CS837 n403 n433 16.875
CS838 n404 n405 18.75
CS839 n404 n434 18.125
CS840 n405 n406 20
CS841 n405 n435 19.375
CS842 n406 n407 21.25
CS843 n406 n436 20.625
CS844 n407 n408 22.5
CS845 n407 n437 21.875
CS846 n408 n409 23.75
CS847 n408 n438 23.125
CS848 n409 n410 25
CS849 n409 n439 24.375
CS850 n410 n411 26.25
CS851 n410 n440 25.625
CS852 n411 n412 27.5
CS853 n411 n441 26.875
CS854 n412 n413 28.75
CS855 n412 n442 28.125
CS856 n413 n414 30
CS857 n413 n443 29.375
CS858 n414 n415 31.25
CS859 n414 n444 30.625
CS860 n415 n416 32.5
CS861 n415 n445 31.875
CS862 n416 n417 33.75
CS863 n416 n446 33.125
CS864 n417 n418 35
CS865 n417 n447 34.375
CS866 n418 n419 36.25
CS867 n418 n448 35.625
CS868 n419 0 37.5
CS869 n419 n449 36.875
CS870 n420 n421 1.25
CS871 n420 n450 0.625
CS872 n421 n422 2.5
CS873 n421 n451 1.875
CS874 n422 n423 3.75
CS875 n422 n452 3.125
CS876 n423 n424 5
CS877 n423 n453 4.375
CS878 n424 n425 6.25
CS879 n424 n454 5.625
CS880 n425 n426 7.5
CS881 n425 n455 6.875
CS882 n426 n427 8.75
CS883 n426 n456 8.125
CS884 n427 n428 10
CS885 n427 n457 9.375
CS886 n428 n429 11.25
CS887 n428 n458 10.625
CS888 n429 n430 12.5
CS889 n429 n459 11.875
CS890 n430 n431 13.75
CS891 n430 n460 13.125
CS892 n431 n432 15
CS893 n431 n461 14.375
CS894 n432 n433 16.25
CS895 n432 n462 15.625
CS896 n433 n434 17.5
CS897 n433 n463 16.875
CS898 n434 n435 18.75
CS899 n434 n464 18.125
CS900 n435 n436 20
CS901 n435 n465 19.375
CS902 n436 n437 21.25
CS903 n436 n466 20.625
CS904 n437 n438 22.5
CS905 n437 n467 21.875
CS906 n438 n439 23.75
CS907 n438 n468 23.125
CS908 n439 n440 25
CS909 n439 n469 24.375
CS910 n440 n441 26.25
CS911 n440 n470 25.625
CS912 n441 n442 27.5
CS913 n441 n471 26.875
CS914 n442 n443 28.75
CS915 n442 n472 28.125
CS916 n443 n444 30
CS917 n443 n473 29.375
CS918 n444 n445 31.25
CS919 n444 n474 30.625
CS920 n445 n446 32.5
CS921 n445 n475 31.875
CS922 n446 n447 33.75
CS923 n446 n476 33.125
CS924 n447 n448 35
CS925 n447 n477 34.375
CS926 n448 n449 36.25
CS927 n448 n478 35.625
CS928 n449 0 37.5
CS929 n449 n479 36.875
CS930 n450 n451 1.25
CS931 n450 n480 0.625
CS932 n451 n452 2.5
CS933 n451 n481 1.875
CS934 n452 n453 3.75
CS935 n452 n482 3.125
CS936 n453 n454 5
CS937 n453 n483 4.375
CS938 n454 n455 6.25
CS939 n454 n484 5.625
CS940 n455 n456 7.5
CS941 n455 n485 6.875
CS942 n456 n457 8.75
CS943 n456 n486 8.125
CS944 n457 n458 10
CS945 n457 n487 9.375
CS946 n458 n459 11.25
CS947 n458 n488 10.625
CS948 n459 n460 12.5
CS949 n459 n489 11.875
CS950 n460 n461 13.75
CS951 n460 n490 13.125
CS952 n461 n462 15
CS953 n461 n491 14.375
CS954 n462 n463 16.25
CS955 n462 n492 15.625
CS956 n463 n464 17.5
CS957 n463 n493 16.875
CS958 n464 n465 18.75
CS959 n464 n494 18.125
CS960 n465 n466 20
CS961 n465 n495 19.375
CS962 n466 n467 21.25
CS963 n466 n496 20.625
CS964 n467 n468 22.5
CS965 n467 n497 21.875
CS966 n468 n469 23.75
CS967 n468 n498 23.125
CS968 n469 n470 25
CS969 n469 n499 24.375
CS970 n470 n471 26.25
CS971 n470 n500 25.625
CS972 n471 n472 27.5
CS973 n471 n501 26.875
CS974 n472 n473 28.75
CS975 n472 n502 28.125
CS976 n473 n474 30
CS977 n473 n503 29.375
CS978 n474 n475 31.25
CS979 n474 n504 30.625
CS980 n475 n476 32.5
CS981 n475 n505 31.875
CS982 n476 n477 33.75
CS983 n476 n506 33.125
CS984 n477 n478 35
CS985 n477 n507 34.375
CS986 n478 n479 36.25
CS987 n478 n508 35.625
CS988 n479 0 37.5
CS989 n479 n509 36.875
CS990 n480 n481 1.25
CS991 n480 n510 0.625
CS992 n481 n482 2.5
CS993 n481 n511 1.875
CS994 n482 n483 3.75
CS995 n482 n512 3.125
CS996 n483 n484 5
CS997 n483 n513 4.375
CS998 n484 n485 6.25
CS999 n484 n514 5.625
CS1000 n485 n486 7.5
CS1001 n485 n515 6.875
CS1002 n486 n487 8.75
CS1003 n486 n516 8.125
CS1004 n487 n488 10
CS1005 n487 n517 9.375
CS1006 n488 n489 11.25
CS1007 n488 n518 10.625
CS1008 n489 n490 12.5
CS1009 n489 n519 11.875
CS1010 n490 n491 13.75
CS1011 n490 n520 13.125
CS1012 n491 n492 15
CS1013 n491 n521 14.375
CS1014 n492 n493 16.25
CS1015 n492 n522 15.625
CS1016 n493 n494 17.5
CS1017 n493 n523 16.875
CS1018 n494 n495 18.75
CS1019 n494 n524 18.125
CS1020 n495 n496 20
CS1021 n495 n525 19.375
CS1022 n496 n497 21.25
CS1023 n496 n526 20.625
CS1024 n497 n498 22.5
CS1025 n497 n527 21.875
CS1026 n498 n499 23.75
CS1027 n498 n528 23.125
CS1028 n499 n500 25
CS1029 n499 n529 24.375
CS1030 n500 n501 26.25
CS1031 n500 n530 25.625
CS1032 n501 n502 27.5
CS1033 n501 n531 26.875
CS1034 n502 n503 28.75
CS1035 n502 n532 28.125
CS1036 n503 n504 30
CS1037 n503 n533 29.375
CS1038 n504 n505 31.25
CS1039 n504 n534 30.625
CS1040 n505 n506 32.5
CS1041 n505 n535 31.875
CS1042 n506 n507 33.75
CS1043 n506 n536 33.125
CS1044 n507 n508 35
CS1045 n507 n537 34.375
CS1046 n508 n509 36.25
CS1047 n508 n538 35.625
CS1048 n509 0 37.5
CS1049 n509 n539 36.875
CS1050 n510 n511 1.25
CS1051 n510 n540 0.625
CS1052 n511 n512 2.5
CS1053 n511 n541 1.875
CS1054 n512 n513 3.75
CS1055 n512 n542 3.125
CS1056 n513 n514 5
CS1057 n513 n543 4.375
CS1058 n514 n515 6.25
CS1059 n514 n544 5.625
CS1060 n515 n516 7.5
CS1061 n515 n545 6.875
CS1062 n516 n517 8.75
CS1063 n516 n546 8.125
CS1064 n517 n518 10
CS1065 n517 n547 9.375
CS1066 n518 n519 11.25
CS1067 n518 n548 10.625
CS1068 n519 n520 12.5
CS1069 n519 n549 11.875
CS1070 n520 n521 13.75
CS1071 n520 n550 13.125
CS1072 n521 n522 15
CS1073 n521 n551 14.375
CS1074 n522 n523 16.25
CS1075 n522 n552 15.625
CS1076 n523 n524 17.5
CS1077 n523 n553 16.875
CS1078 n524 n525 18.75
CS1079 n524 n554 18.125
CS1080 n525 n526 20
CS1081 n525 n555 19.375
CS1082 n526 n527 21.25
CS1083 n526 n556 20.625
CS1084 n527 n528 22.5
CS1085 n527 n557 21.875
CS1086 n528 n529 23.75
CS1087 n528 n558 23.125
CS1088 n529 n530 25
CS1089 n529 n559 24.375
CS1090 n530 n531 26.25
CS1091 n530 n560 25.625
CS1092 n531 n532 27.5
CS1093 n531 n561 26.875
CS1094 n532 n533 28.75
CS1095 n532 n562 28.125
CS1096 n533 n534 30
CS1097 n533 n563 29.375
CS1098 n534 n535 31.25
CS1099 n534 n564 30.625
CS1100 n535 n536 32.5
CS1101 n535 n565 31.875
CS1102 n536 n537 33.75
CS1103 n536 n566 33.125
CS1104 n537 n538 35
CS1105 n537 n567 34.375
CS1106 n538 n539 36.25
CS1107 n538 n568 35.625
CS1108 n539 0 37.5
CS1109 n539 n569 36.875
CS1110 n540 n541 1.25
CS1111 n540 n570 0.625
CS1112 n541 n542 2.5
CS1113 n541 n571 1.875
CS1114 n542 n543 3.75
CS1115 n542 n572 3.125
CS1116 n543 n544 5
CS1117 n543 n573 4.375
CS1118 n544 n545 6.25
CS1119 n544 n574 5.625
CS1120 n545 n546 7.5
CS1121 n545 n575 6.875
CS1122 n546 n547 8.75
CS1123 n546 n576 8.125
CS1124 n547 n548 10
CS1125 n547 n577 9.375
CS1126 n548 n549 11.25
CS1127 n548 n578 10.625
CS1128 n549 n550 12.5
CS1129 n549 n579 11.875
CS1130 n550 n551 13.75
CS1131 n550 n580 13.125
CS1132 n551 n552 15
CS1133 n551 n581 14.375
CS1134 n552 n553 16.25
CS1135 n552 n582 15.625
CS1136 n553 n554 17.5
CS1137 n553 n583 16.875
CS1138 n554 n555 18.75
CS1139 n554 n584 18.125
CS1140 n555 n556 20
CS1141 n555 n585 19.375
CS1142 n556 n557 21.25
CS1143 n556 n586 20.625
CS1144 n557 n558 22.5
CS1145 n557 n587 21.875
CS1146 n558 n559 23.75
CS1147 n558 n588 23.125
CS1148 n559 n560 25
CS1149 n559 n589 24.375
CS1150 n560 n561 26.25
CS1151 n560 n590 25.625
CS1152 n561 n562 27.5
CS1153 n561 n591 26.875
CS1154 n562 n563 28.75
CS1155 n562 n592 28.125
CS1156 n563 n564 30
CS1157 n563 n593 29.375
CS1158 n564 n565 31.25
CS1159 n564 n594 30.625
CS1160 n565 n566 32.5
CS1161 n565 n595 31.875
CS1162 n566 n567 33.75
CS1163 n566 n596 33.125
CS1164 n567 n568 35
CS1165 n567 n597 34.375
CS1166 n568 n569 36.25
CS1167 n568 n598 35.625
CS1168 n569 0 37.5
CS1169 n569 n599 36.875
CS1170 n570 n571 1.25
CS1171 n570 n600 0.625
CS1172 n571 n572 2.5
CS1173 n571 n601 1.875
CS1174 n572 n573 3.75
CS1175 n572 n602 3.125
CS1176 n573 n574 5
CS1177 n573 n603 4.375
CS1178 n574 n575 6.25
CS1179 n574 n604 5.625
CS1180 n575 n576 7.5
CS1181 n575 n605 6.875
CS1182 n576 n577 8.75
CS1183 n576 n606 8.125
CS1184 n577 n578 10
CS1185 n577 n607 9.375
CS1186 n578 n579 11.25
CS1187 n578 n608 10.625
CS1188 n579 n580 12.5
CS1189 n579 n609 11.875
CS1190 n580 n581 13.75
CS1191 n580 n610 13.125
CS1192 n581 n582 15
CS1193 n581 n611 14.375
CS1194 n582 n583 16.25
CS1195 n582 n612 15.625
CS1196 n583 n584 17.5
CS1197 n583 n613 16.875
CS1198 n584 n585 18.75
CS1199 n584 n614 18.125
CS1200 n585 n586 20
CS1201 n585 n615 19.375
CS1202 n586 n587 21.25
CS1203 n586 n616 20.625
CS1204 n587 n588 22.5
CS1205 n587 n617 21.875
CS1206 n588 n589 23.75
CS1207 n588 n618 23.125
CS1208 n589 n590 25
CS1209 n589 n619 24.375
CS1210 n590 n591 26.25
CS1211 n590 n620 25.625
CS1212 n591 n592 27.5
CS1213 n591 n621 26.875
CS1214 n592 n593 28.75
CS1215 n592 n622 28.125
CS1216 n593 n594 30
CS1217 n593 n623 29.375
CS1218 n594 n595 31.25
CS1219 n594 n624 30.625
CS1220 n595 n596 32.5
CS1221 n595 n625 31.875
CS1222 n596 n597 33.75
CS1223 n596 n626 33.125
CS1224 n597 n598 35
CS1225 n597 n627 34.375
CS1226 n598 n599 36.25
CS1227 n598 n628 35.625
CS1228 n599 0 37.5
CS1229 n599 n629 36.875
CS1230 n600 n601 1.25
CS1231 n600 n630 0.625
CS1232 n601 n602 2.5
CS1233 n601 n631 1.875
CS1234 n602 n603 3.75
CS1235 n602 n632 3.125
CS1236 n603 n604 5
CS1237 n603 n633 4.375
CS1238 n604 n605 6.25
CS1239 n604 n634 5.625
CS1240 n605 n606 7.5
CS1241 n605 n635 6.875
CS1242 n606 n607 8.75
CS1243 n606 n636 8.125
CS1244 n607 n608 10
CS1245 n607 n637 9.375
CS1246 n608 n609 11.25
CS1247 n608 n638 10.625
CS1248 n609 n610 12.5
CS1249 n609 n639 11.875
CS1250 n610 n611 13.75
CS1251 n610 n640 13.125
CS1252 n611 n612 15
CS1253 n611 n641 14.375
CS1254 n612 n613 16.25
CS1255 n612 n642 15.625
CS1256 n613 n614 17.5
CS1257 n613 n643 16.875
CS1258 n614 n615 18.75
CS1259 n614 n644 18.125
CS1260 n615 n616 20
CS1261 n615 n645 19.375
CS1262 n616 n617 21.25
CS1263 n616 n646 20.625
CS1264 n617 n618 22.5
CS1265 n617 n647 21.875
CS1266 n618 n619 23.75
CS1267 n618 n648 23.125
CS1268 n619 n620 25
CS1269 n619 n649 24.375
CS1270 n620 n621 26.25
CS1271 n620 n650 25.625
CS1272 n621 n622 27.5
CS1273 n621 n651 26.875
CS1274 n622 n623 28.75
CS1275 n622 n652 28.125
CS1276 n623 n624 30
CS1277 n623 n653 29.375
CS1278 n624 n625 31.25
CS1279 n624 n654 30.625
CS1280 n625 n626 32.5
CS1281 n625 n655 31.875
CS1282 n626 n627 33.75
CS1283 n626 n656 33.125
CS1284 n627 n628 35
CS1285 n627 n657 34.375
CS1286 n628 n629 36.25
CS1287 n628 n658 35.625
CS1288 n629 0 37.5
CS1289 n629 n659 36.875
CS1290 n630 n631 1.25
CS1291 n630 n660 0.625
CS1292 n631 n632 2.5
CS1293 n631 n661 1.875
CS1294 n632 n633 3.75
CS1295 n632 n662 3.125
CS1296 n633 n634 5
CS1297 n633 n663 4.375
CS1298 n634 n635 6.25
CS1299 n634 n664 5.625
CS1300 n635 n636 7.5
CS1301 n635 n665 6.875
CS1302 n636 n637 8.75
CS1303 n636 n666 8.125
CS1304 n637 n638 10
CS1305 n637 n667 9.375
CS1306 n638 n639 11.25
CS1307 n638 n668 10.625
CS1308 n639 n640 12.5
CS1309 n639 n669 11.875
CS1310 n640 n641 13.75
CS1311 n640 n670 13.125
CS1312 n641 n642 15
CS1313 n641 n671 14.375
CS1314 n642 n643 16.25
CS1315 n642 n672 15.625
CS1316 n643 n644 17.5
CS1317 n643 n673 16.875
CS1318 n644 n645 18.75
CS1319 n644 n674 18.125
CS1320 n645 n646 20
CS1321 n645 n675 19.375
CS1322 n646 n647 21.25
CS1323 n646 n676 20.625
CS1324 n647 n648 22.5
CS1325 n647 n677 21.875
CS1326 n648 n649 23.75
CS1327 n648 n678 23.125
CS1328 n649 n650 25
CS1329 n649 n679 24.375
CS1330 n650 n651 26.25
CS1331 n650 n680 25.625
CS1332 n651 n652 27.5
CS1333 n651 n681 26.875
CS1334 n652 n653 28.75
CS1335 n652 n682 28.125
CS1336 n653 n654 30
CS1337 n653 n683 29.375
CS1338 n654 n655 31.25
CS1339 n654 n684 30.625
CS1340 n655 n656 32.5
CS1341 n655 n685 31.875
CS1342 n656 n657 33.75
CS1343 n656 n686 33.125
CS1344 n657 n658 35
CS1345 n657 n687 34.375
CS1346 n658 n659 36.25
CS1347 n658 n688 35.625
CS1348 n659 0 37.5
CS1349 n659 n689 36.875
CS1350 n660 n661 1.25
CS1351 n660 n690 0.625
CS1352 n661 n662 2.5
CS1353 n661 n691 1.875
CS1354 n662 n663 3.75
CS1355 n662 n692 3.125
CS1356 n663 n664 5
CS1357 n663 n693 4.375
CS1358 n664 n665 6.25
CS1359 n664 n694 5.625
CS1360 n665 n666 7.5
CS1361 n665 n695 6.875
CS1362 n666 n667 8.75
CS1363 n666 n696 8.125
CS1364 n667 n668 10
CS1365 n667 n697 9.375
CS1366 n668 n669 11.25
CS1367 n668 n698 10.625
CS1368 n669 n670 12.5
CS1369 n669 n699 11.875
CS1370 n670 n671 13.75
CS1371 n670 n700 13.125
CS1372 n671 n672 15
CS1373 n671 n701 14.375
CS1374 n672 n673 16.25
CS1375 n672 n702 15.625
CS1376 n673 n674 17.5
CS1377 n673 n703 16.875
CS1378 n674 n675 18.75
CS1379 n674 n704 18.125
CS1380 n675 n676 20
CS1381 n675 n705 19.375
CS1382 n676 n677 21.25
CS1383 n676 n706 20.625
CS1384 n677 n678 22.5
CS1385 n677 n707 21.875
CS1386 n678 n679 23.75
CS1387 n678 n708 23.125
CS1388 n679 n680 25
CS1389 n679 n709 24.375
CS1390 n680 n681 26.25
CS1391 n680 n710 25.625
CS1392 n681 n682 27.5
CS1393 n681 n711 26.875
CS1394 n682 n683 28.75
CS1395 n682 n712 28.125
CS1396 n683 n684 30
CS1397 n683 n713 29.375
CS1398 n684 n685 31.25
CS1399 n684 n714 30.625
CS1400 n685 n686 32.5
CS1401 n685 n715 31.875
CS1402 n686 n687 33.75
CS1403 n686 n716 33.125
CS1404 n687 n688 35
CS1405 n687 n717 34.375
CS1406 n688 n689 36.25
CS1407 n688 n718 35.625
CS1408 n689 0 37.5
CS1409 n689 n719 36.875
CS1410 n690 n691 1.25
CS1411 n690 n720 0.625
CS1412 n691 n692 2.5
CS1413 n691 n721 1.875
CS1414 n692 n693 3.75
CS1415 n692 n722 3.125
CS1416 n693 n694 5
CS1417 n693 n723 4.375
CS1418 n694 n695 6.25
CS1419 n694 n724 5.625
CS1420 n695 n696 7.5
CS1421 n695 n725 6.875
CS1422 n696 n697 8.75
CS1423 n696 n726 8.125
CS1424 n697 n698 10
CS1425 n697 n727 9.375
CS1426 n698 n699 11.25
CS1427 n698 n728 10.625
CS1428 n699 n700 12.5
CS1429 n699 n729 11.875
CS1430 n700 n701 13.75
CS1431 n700 n730 13.125
CS1432 n701 n702 15
CS1433 n701 n731 14.375
CS1434 n702 n703 16.25
CS1435 n702 n732 15.625
CS1436 n703 n704 17.5
CS1437 n703 n733 16.875
CS1438 n704 n705 18.75
CS1439 n704 n734 18.125
CS1440 n705 n706 20
CS1441 n705 n735 19.375
CS1442 n706 n707 21.25
CS1443 n706 n736 20.625
CS1444 n707 n708 22.5
CS1445 n707 n737 21.875
CS1446 n708 n709 23.75
CS1447 n708 n738 23.125
CS1448 n709 n710 25
CS1449 n709 n739 24.375
CS1450 n710 n711 26.25
CS1451 n710 n740 25.625
CS1452 n711 n712 27.5
CS1453 n711 n741 26.875
CS1454 n712 n713 28.75
CS1455 n712 n742 28.125
CS1456 n713 n714 30
CS1457 n713 n743 29.375
CS1458 n714 n715 31.25
CS1459 n714 n744 30.625
CS1460 n715 n716 32.5
CS1461 n715 n745 31.875
CS1462 n716 n717 33.75
CS1463 n716 n746 33.125
CS1464 n717 n718 35
CS1465 n717 n747 34.375
CS1466 n718 n719 36.25
CS1467 n718 n748 35.625
CS1468 n719 0 37.5
CS1469 n719 n749 36.875
CS1470 n720 n721 1.25
CS1471 n720 n750 0.625
CS1472 n721 n722 2.5
CS1473 n721 n751 1.875
CS1474 n722 n723 3.75
CS1475 n722 n752 3.125
CS1476 n723 n724 5
CS1477 n723 n753 4.375
CS1478 n724 n725 6.25
CS1479 n724 n754 5.625
CS1480 n725 n726 7.5
CS1481 n725 n755 6.875
CS1482 n726 n727 8.75
CS1483 n726 n756 8.125
CS1484 n727 n728 10
CS1485 n727 n757 9.375
CS1486 n728 n729 11.25
CS1487 n728 n758 10.625
CS1488 n729 n730 12.5
CS1489 n729 n759 11.875
CS1490 n730 n731 13.75
CS1491 n730 n760 13.125
CS1492 n731 n732 15
CS1493 n731 n761 14.375
CS1494 n732 n733 16.25
CS1495 n732 n762 15.625
CS1496 n733 n734 17.5
CS1497 n733 n763 16.875
CS1498 n734 n735 18.75
CS1499 n734 n764 18.125
CS1500 n735 n736 20
CS1501 n735 n765 19.375
CS1502 n736 n737 21.25
CS1503 n736 n766 20.625
CS1504 n737 n738 22.5
CS1505 n737 n767 21.875
CS1506 n738 n739 23.75
CS1507 n738 n768 23.125
CS1508 n739 n740 25
CS1509 n739 n769 24.375
CS1510 n740 n741 26.25
CS1511 n740 n770 25.625
CS1512 n741 n742 27.5
CS1513 n741 n771 26.875
CS1514 n742 n743 28.75
CS1515 n742 n772 28.125
CS1516 n743 n744 30
CS1517 n743 n773 29.375
CS1518 n744 n745 31.25
CS1519 n744 n774 30.625
CS1520 n745 n746 32.5
CS1521 n745 n775 31.875
CS1522 n746 n747 33.75
CS1523 n746 n776 33.125
CS1524 n747 n748 35
CS1525 n747 n777 34.375
CS1526 n748 n749 36.25
CS1527 n748 n778 35.625
CS1528 n749 0 37.5
CS1529 n749 n779 36.875
CS1530 n750 n751 1.25
CS1531 n750 n780 0.625
CS1532 n751 n752 2.5
CS1533 n751 n781 1.875
CS1534 n752 n753 3.75
CS1535 n752 n782 3.125
CS1536 n753 n754 5
CS1537 n753 n783 4.375
CS1538 n754 n755 6.25
CS1539 n754 n784 5.625
CS1540 n755 n756 7.5
CS1541 n755 n785 6.875
CS1542 n756 n757 8.75
CS1543 n756 n786 8.125
CS1544 n757 n758 10
CS1545 n757 n787 9.375
CS1546 n758 n759 11.25
CS1547 n758 n788 10.625
CS1548 n759 n760 12.5
CS1549 n759 n789 11.875
CS1550 n760 n761 13.75
CS1551 n760 n790 13.125
CS1552 n761 n762 15
CS1553 n761 n791 14.375
CS1554 n762 n763 16.25
CS1555 n762 n792 15.625
CS1556 n763 n764 17.5
CS1557 n763 n793 16.875
CS1558 n764 n765 18.75
CS1559 n764 n794 18.125
CS1560 n765 n766 20
CS1561 n765 n795 19.375
CS1562 n766 n767 21.25
CS1563 n766 n796 20.625
CS1564 n767 n768 22.5
CS1565 n767 n797 21.875
CS1566 n768 n769 23.75
CS1567 n768 n798 23.125
CS1568 n769 n770 25
CS1569 n769 n799 24.375
CS1570 n770 n771 26.25
CS1571 n770 n800 25.625
CS1572 n771 n772 27.5
CS1573 n771 n801 26.875
CS1574 n772 n773 28.75
CS1575 n772 n802 28.125
CS1576 n773 n774 30
CS1577 n773 n803 29.375
CS1578 n774 n775 31.25
CS1579 n774 n804 30.625
CS1580 n775 n776 32.5
CS1581 n775 n805 31.875
CS1582 n776 n777 33.75
CS1583 n776 n806 33.125
CS1584 n777 n778 35
CS1585 n777 n807 34.375
CS1586 n778 n779 36.25
CS1587 n778 n808 35.625
CS1588 n779 0 37.5
CS1589 n779 n809 36.875
CS1590 n780 n781 1.25
CS1591 n780 n810 0.625
CS1592 n781 n782 2.5
CS1593 n781 n811 1.875
CS1594 n782 n783 3.75
CS1595 n782 n812 3.125
CS1596 n783 n784 5
CS1597 n783 n813 4.375
CS1598 n784 n785 6.25
CS1599 n784 n814 5.625
CS1600 n785 n786 7.5
CS1601 n785 n815 6.875
CS1602 n786 n787 8.75
CS1603 n786 n816 8.125
CS1604 n787 n788 10
CS1605 n787 n817 9.375
CS1606 n788 n789 11.25
CS1607 n788 n818 10.625
CS1608 n789 n790 12.5
CS1609 n789 n819 11.875
CS1610 n790 n791 13.75
CS1611 n790 n820 13.125
CS1612 n791 n792 15
CS1613 n791 n821 14.375
CS1614 n792 n793 16.25
CS1615 n792 n822 15.625
CS1616 n793 n794 17.5
CS1617 n793 n823 16.875
CS1618 n794 n795 18.75
CS1619 n794 n824 18.125
CS1620 n795 n796 20
CS1621 n795 n825 19.375
CS1622 n796 n797 21.25
CS1623 n796 n826 20.625
CS1624 n797 n798 22.5
CS1625 n797 n827 21.875
CS1626 n798 n799 23.75
CS1627 n798 n828 23.125
CS1628 n799 n800 25
CS1629 n799 n829 24.375
CS1630 n800 n801 26.25
CS1631 n800 n830 25.625
CS1632 n801 n802 27.5
CS1633 n801 n831 26.875
CS1634 n802 n803 28.75
CS1635 n802 n832 28.125
CS1636 n803 n804 30
CS1637 n803 n833 29.375
CS1638 n804 n805 31.25
CS1639 n804 n834 30.625
CS1640 n805 n806 32.5
CS1641 n805 n835 31.875
CS1642 n806 n807 33.75
CS1643 n806 n836 33.125
CS1644 n807 n808 35
CS1645 n807 n837 34.375
CS1646 n808 n809 36.25
CS1647 n808 n838 35.625
CS1648 n809 0 37.5
CS1649 n809 n839 36.875
CS1650 n810 n811 1.25
CS1651 n810 n840 0.625
CS1652 n811 n812 2.5
CS1653 n811 n841 1.875
CS1654 n812 n813 3.75
CS1655 n812 n842 3.125
CS1656 n813 n814 5
CS1657 n813 n843 4.375
CS1658 n814 n815 6.25
CS1659 n814 n844 5.625
CS1660 n815 n816 7.5
CS1661 n815 n845 6.875
CS1662 n816 n817 8.75
CS1663 n816 n846 8.125
CS1664 n817 n818 10
CS1665 n817 n847 9.375
CS1666 n818 n819 11.25
CS1667 n818 n848 10.625
CS1668 n819 n820 12.5
CS1669 n819 n849 11.875
CS1670 n820 n821 13.75
CS1671 n820 n850 13.125
CS1672 n821 n822 15
CS1673 n821 n851 14.375
CS1674 n822 n823 16.25
CS1675 n822 n852 15.625
CS1676 n823 n824 17.5
CS1677 n823 n853 16.875
CS1678 n824 n825 18.75
CS1679 n824 n854 18.125
CS1680 n825 n826 20
CS1681 n825 n855 19.375
CS1682 n826 n827 21.25
CS1683 n826 n856 20.625
CS1684 n827 n828 22.5
CS1685 n827 n857 21.875
CS1686 n828 n829 23.75
CS1687 n828 n858 23.125
CS1688 n829 n830 25
CS1689 n829 n859 24.375
CS1690 n830 n831 26.25
CS1691 n830 n860 25.625
CS1692 n831 n832 27.5
CS1693 n831 n861 26.875
CS1694 n832 n833 28.75
CS1695 n832 n862 28.125
CS1696 n833 n834 30
CS1697 n833 n863 29.375
CS1698 n834 n835 31.25
CS1699 n834 n864 30.625
CS1700 n835 n836 32.5
CS1701 n835 n865 31.875
CS1702 n836 n837 33.75
CS1703 n836 n866 33.125
CS1704 n837 n838 35
CS1705 n837 n867 34.375
CS1706 n838 n839 36.25
CS1707 n838 n868 35.625
CS1708 n839 0 37.5
CS1709 n839 n869 36.875
CS1710 n840 n841 1.25
CS1711 n840 n870 0.625
CS1712 n841 n842 2.5
CS1713 n841 n871 1.875
CS1714 n842 n843 3.75
CS1715 n842 n872 3.125
CS1716 n843 n844 5
CS1717 n843 n873 4.375
CS1718 n844 n845 6.25
CS1719 n844 n874 5.625
CS1720 n845 n846 7.5
CS1721 n845 n875 6.875
CS1722 n846 n847 8.75
CS1723 n846 n876 8.125
CS1724 n847 n848 10
CS1725 n847 n877 9.375
CS1726 n848 n849 11.25
CS1727 n848 n878 10.625
CS1728 n849 n850 12.5
CS1729 n849 n879 11.875
CS1730 n850 n851 13.75
CS1731 n850 n880 13.125
CS1732 n851 n852 15
CS1733 n851 n881 14.375
CS1734 n852 n853 16.25
CS1735 n852 n882 15.625
CS1736 n853 n854 17.5
CS1737 n853 n883 16.875
CS1738 n854 n855 18.75
CS1739 n854 n884 18.125
CS1740 n855 n856 20
CS1741 n855 n885 19.375
CS1742 n856 n857 21.25
CS1743 n856 n886 20.625
CS1744 n857 n858 22.5
CS1745 n857 n887 21.875
CS1746 n858 n859 23.75
CS1747 n858 n888 23.125
CS1748 n859 n860 25
CS1749 n859 n889 24.375
CS1750 n860 n861 26.25
CS1751 n860 n890 25.625
CS1752 n861 n862 27.5
CS1753 n861 n891 26.875
CS1754 n862 n863 28.75
CS1755 n862 n892 28.125
CS1756 n863 n864 30
CS1757 n863 n893 29.375
CS1758 n864 n865 31.25
CS1759 n864 n894 30.625
CS1760 n865 n866 32.5
CS1761 n865 n895 31.875
CS1762 n866 n867 33.75
CS1763 n866 n896 33.125
CS1764 n867 n868 35
CS1765 n867 n897 34.375
CS1766 n868 n869 36.25
CS1767 n868 n898 35.625
CS1768 n869 0 37.5
CS1769 n869 n899 36.875
CS1770 n870 n871 1.25
CS1771 n870 n900 0.625
CS1772 n871 n872 2.5
CS1773 n871 n901 1.875
CS1774 n872 n873 3.75
CS1775 n872 n902 3.125
CS1776 n873 n874 5
CS1777 n873 n903 4.375
CS1778 n874 n875 6.25
CS1779 n874 n904 5.625
CS1780 n875 n876 7.5
CS1781 n875 n905 6.875
CS1782 n876 n877 8.75
CS1783 n876 n906 8.125
CS1784 n877 n878 10
CS1785 n877 n907 9.375
CS1786 n878 n879 11.25
CS1787 n878 n908 10.625
CS1788 n879 n880 12.5
CS1789 n879 n909 11.875
CS1790 n880 n881 13.75
CS1791 n880 n910 13.125
CS1792 n881 n882 15
CS1793 n881 n911 14.375
CS1794 n882 n883 16.25
CS1795 n882 n912 15.625
CS1796 n883 n884 17.5
CS1797 n883 n913 16.875
CS1798 n884 n885 18.75
CS1799 n884 n914 18.125
CS1800 n885 n886 20
CS1801 n885 n915 19.375
CS1802 n886 n887 21.25
CS1803 n886 n916 20.625
CS1804 n887 n888 22.5
CS1805 n887 n917 21.875
CS1806 n888 n889 23.75
CS1807 n888 n918 23.125
CS1808 n889 n890 25
CS1809 n889 n919 24.375
CS1810 n890 n891 26.25
CS1811 n890 n920 25.625
CS1812 n891 n892 27.5
CS1813 n891 n921 26.875
CS1814 n892 n893 28.75
CS1815 n892 n922 28.125
CS1816 n893 n894 30
CS1817 n893 n923 29.375
CS1818 n894 n895 31.25
CS1819 n894 n924 30.625
CS1820 n895 n896 32.5
CS1821 n895 n925 31.875
CS1822 n896 n897 33.75
CS1823 n896 n926 33.125
CS1824 n897 n898 35
CS1825 n897 n927 34.375
CS1826 n898 n899 36.25
CS1827 n898 n928 35.625
CS1828 n899 0 37.5
CS1829 n899 n929 36.875
CS1830 n900 n901 1.25
CS1831 n900 n930 0.625
CS1832 n901 n902 2.5
CS1833 n901 n931 1.875
CS1834 n902 n903 3.75
CS1835 n902 n932 3.125
CS1836 n903 n904 5
CS1837 n903 n933 4.375
CS1838 n904 n905 6.25
CS1839 n904 n934 5.625
CS1840 n905 n906 7.5
CS1841 n905 n935 6.875
CS1842 n906 n907 8.75
CS1843 n906 n936 8.125
CS1844 n907 n908 10
CS1845 n907 n937 9.375
CS1846 n908 n909 11.25
CS1847 n908 n938 10.625
CS1848 n909 n910 12.5
CS1849 n909 n939 11.875
CS1850 n910 n911 13.75
CS1851 n910 n940 13.125
CS1852 n911 n912 15
CS1853 n911 n941 14.375
CS1854 n912 n913 16.25
CS1855 n912 n942 15.625
CS1856 n913 n914 17.5
CS1857 n913 n943 16.875
CS1858 n914 n915 18.75
CS1859 n914 n944 18.125
CS1860 n915 n916 20
CS1861 n915 n945 19.375
CS1862 n916 n917 21.25
CS1863 n916 n946 20.625
CS1864 n917 n918 22.5
CS1865 n917 n947 21.875
CS1866 n918 n919 23.75
CS1867 n918 n948 23.125
CS1868 n919 n920 25
CS1869 n919 n949 24.375
CS1870 n920 n921 26.25
CS1871 n920 n950 25.625
CS1872 n921 n922 27.5
CS1873 n921 n951 26.875
CS1874 n922 n923 28.75
CS1875 n922 n952 28.125
CS1876 n923 n924 30
CS1877 n923 n953 29.375
CS1878 n924 n925 31.25
CS1879 n924 n954 30.625
CS1880 n925 n926 32.5
CS1881 n925 n955 31.875
CS1882 n926 n927 33.75
CS1883 n926 n956 33.125
CS1884 n927 n928 35
CS1885 n927 n957 34.375
CS1886 n928 n929 36.25
CS1887 n928 n958 35.625
CS1888 n929 0 37.5
CS1889 n929 n959 36.875
CS1890 n930 n931 1.25
CS1891 n930 n960 0.625
CS1892 n931 n932 2.5
CS1893 n931 n961 1.875
CS1894 n932 n933 3.75
CS1895 n932 n962 3.125
CS1896 n933 n934 5
CS1897 n933 n963 4.375
CS1898 n934 n935 6.25
CS1899 n934 n964 5.625
CS1900 n935 n936 7.5
CS1901 n935 n965 6.875
CS1902 n936 n937 8.75
CS1903 n936 n966 8.125
CS1904 n937 n938 10
CS1905 n937 n967 9.375
CS1906 n938 n939 11.25
CS1907 n938 n968 10.625
CS1908 n939 n940 12.5
CS1909 n939 n969 11.875
CS1910 n940 n941 13.75
CS1911 n940 n970 13.125
CS1912 n941 n942 15
CS1913 n941 n971 14.375
CS1914 n942 n943 16.25
CS1915 n942 n972 15.625
CS1916 n943 n944 17.5
CS1917 n943 n973 16.875
CS1918 n944 n945 18.75
CS1919 n944 n974 18.125
CS1920 n945 n946 20
CS1921 n945 n975 19.375
CS1922 n946 n947 21.25
CS1923 n946 n976 20.625
CS1924 n947 n948 22.5
CS1925 n947 n977 21.875
CS1926 n948 n949 23.75
CS1927 n948 n978 23.125
CS1928 n949 n950 25
CS1929 n949 n979 24.375
CS1930 n950 n951 26.25
CS1931 n950 n980 25.625
CS1932 n951 n952 27.5
CS1933 n951 n981 26.875
CS1934 n952 n953 28.75
CS1935 n952 n982 28.125
CS1936 n953 n954 30
CS1937 n953 n983 29.375
CS1938 n954 n955 31.25
CS1939 n954 n984 30.625
CS1940 n955 n956 32.5
CS1941 n955 n985 31.875
CS1942 n956 n957 33.75
CS1943 n956 n986 33.125
CS1944 n957 n958 35
CS1945 n957 n987 34.375
CS1946 n958 n959 36.25
CS1947 n958 n988 35.625
CS1948 n959 0 37.5
CS1949 n959 n989 36.875
CS1950 n960 n961 1.25
CS1951 n960 n990 0.625
CS1952 n961 n962 2.5
CS1953 n961 n991 1.875
CS1954 n962 n963 3.75
CS1955 n962 n992 3.125
CS1956 n963 n964 5
CS1957 n963 n993 4.375
CS1958 n964 n965 6.25
CS1959 n964 n994 5.625
CS1960 n965 n966 7.5
CS1961 n965 n995 6.875
CS1962 n966 n967 8.75
CS1963 n966 n996 8.125
CS1964 n967 n968 10
CS1965 n967 n997 9.375
CS1966 n968 n969 11.25
CS1967 n968 n998 10.625
CS1968 n969 n970 12.5
CS1969 n969 n999 11.875
CS1970 n970 n971 13.75
CS1971 n970 n1000 13.125
CS1972 n971 n972 15
CS1973 n971 n1001 14.375
CS1974 n972 n973 16.25
CS1975 n972 n1002 15.625
CS1976 n973 n974 17.5
CS1977 n973 n1003 16.875
CS1978 n974 n975 18.75
CS1979 n974 n1004 18.125
CS1980 n975 n976 20
CS1981 n975 n1005 19.375
CS1982 n976 n977 21.25
CS1983 n976 n1006 20.625
CS1984 n977 n978 22.5
CS1985 n977 n1007 21.875
CS1986 n978 n979 23.75
CS1987 n978 n1008 23.125
CS1988 n979 n980 25
CS1989 n979 n1009 24.375
CS1990 n980 n981 26.25
CS1991 n980 n1010 25.625
CS1992 n981 n982 27.5
CS1993 n981 n1011 26.875
CS1994 n982 n983 28.75
CS1995 n982 n1012 28.125
CS1996 n983 n984 30
CS1997 n983 n1013 29.375
CS1998 n984 n985 31.25
CS1999 n984 n1014 30.625
CS2000 n985 n986 32.5
CS2001 n985 n1015 31.875
CS2002 n986 n987 33.75
CS2003 n986 n1016 33.125
CS2004 n987 n988 35
CS2005 n987 n1017 34.375
CS2006 n988 n989 36.25
CS2007 n988 n1018 35.625
CS2008 n989 0 37.5
CS2009 n989 n1019 36.875
CS2010 n990 n991 1.25
CS2011 n990 n1020 0.625
CS2012 n991 n992 2.5
CS2013 n991 n1021 1.875
CS2014 n992 n993 3.75
CS2015 n992 n1022 3.125
CS2016 n993 n994 5
CS2017 n993 n1023 4.375
CS2018 n994 n995 6.25
CS2019 n994 n1024 5.625
CS2020 n995 n996 7.5
CS2021 n995 n1025 6.875
CS2022 n996 n997 8.75
CS2023 n996 n1026 8.125
CS2024 n997 n998 10
CS2025 n997 n1027 9.375
CS2026 n998 n999 11.25
CS2027 n998 n1028 10.625
CS2028 n999 n1000 12.5
CS2029 n999 n1029 11.875
CS2030 n1000 n1001 13.75
CS2031 n1000 n1030 13.125
CS2032 n1001 n1002 15
CS2033 n1001 n1031 14.375
CS2034 n1002 n1003 16.25
CS2035 n1002 n1032 15.625
CS2036 n1003 n1004 17.5
CS2037 n1003 n1033 16.875
CS2038 n1004 n1005 18.75
CS2039 n1004 n1034 18.125
CS2040 n1005 n1006 20
CS2041 n1005 n1035 19.375
CS2042 n1006 n1007 21.25
CS2043 n1006 n1036 20.625
CS2044 n1007 n1008 22.5
CS2045 n1007 n1037 21.875
CS2046 n1008 n1009 23.75
CS2047 n1008 n1038 23.125
CS2048 n1009 n1010 25
CS2049 n1009 n1039 24.375
CS2050 n1010 n1011 26.25
CS2051 n1010 n1040 25.625
CS2052 n1011 n1012 27.5
CS2053 n1011 n1041 26.875
CS2054 n1012 n1013 28.75
CS2055 n1012 n1042 28.125
CS2056 n1013 n1014 30
CS2057 n1013 n1043 29.375
CS2058 n1014 n1015 31.25
CS2059 n1014 n1044 30.625
CS2060 n1015 n1016 32.5
CS2061 n1015 n1045 31.875
CS2062 n1016 n1017 33.75
CS2063 n1016 n1046 33.125
CS2064 n1017 n1018 35
CS2065 n1017 n1047 34.375
CS2066 n1018 n1019 36.25
CS2067 n1018 n1048 35.625
CS2068 n1019 0 37.5
CS2069 n1019 n1049 36.875
CS2070 n1020 n1021 1.25
CS2071 n1020 n1050 0.625
CS2072 n1021 n1022 2.5
CS2073 n1021 n1051 1.875
CS2074 n1022 n1023 3.75
CS2075 n1022 n1052 3.125
CS2076 n1023 n1024 5
CS2077 n1023 n1053 4.375
CS2078 n1024 n1025 6.25
CS2079 n1024 n1054 5.625
CS2080 n1025 n1026 7.5
CS2081 n1025 n1055 6.875
CS2082 n1026 n1027 8.75
CS2083 n1026 n1056 8.125
CS2084 n1027 n1028 10
CS2085 n1027 n1057 9.375
CS2086 n1028 n1029 11.25
CS2087 n1028 n1058 10.625
CS2088 n1029 n1030 12.5
CS2089 n1029 n1059 11.875
CS2090 n1030 n1031 13.75
CS2091 n1030 n1060 13.125
CS2092 n1031 n1032 15
CS2093 n1031 n1061 14.375
CS2094 n1032 n1033 16.25
CS2095 n1032 n1062 15.625
CS2096 n1033 n1034 17.5
CS2097 n1033 n1063 16.875
CS2098 n1034 n1035 18.75
CS2099 n1034 n1064 18.125
CS2100 n1035 n1036 20
CS2101 n1035 n1065 19.375
CS2102 n1036 n1037 21.25
CS2103 n1036 n1066 20.625
CS2104 n1037 n1038 22.5
CS2105 n1037 n1067 21.875
CS2106 n1038 n1039 23.75
CS2107 n1038 n1068 23.125
CS2108 n1039 n1040 25
CS2109 n1039 n1069 24.375
CS2110 n1040 n1041 26.25
CS2111 n1040 n1070 25.625
CS2112 n1041 n1042 27.5
CS2113 n1041 n1071 26.875
CS2114 n1042 n1043 28.75
CS2115 n1042 n1072 28.125
CS2116 n1043 n1044 30
CS2117 n1043 n1073 29.375
CS2118 n1044 n1045 31.25
CS2119 n1044 n1074 30.625
CS2120 n1045 n1046 32.5
CS2121 n1045 n1075 31.875
CS2122 n1046 n1047 33.75
CS2123 n1046 n1076 33.125
CS2124 n1047 n1048 35
CS2125 n1047 n1077 34.375
CS2126 n1048 n1049 36.25
CS2127 n1048 n1078 35.625
CS2128 n1049 0 37.5
CS2129 n1049 n1079 36.875
CS2130 n1050 n1051 1.25
CS2131 n1050 n1080 0.625
CS2132 n1051 n1052 2.5
CS2133 n1051 n1081 1.875
CS2134 n1052 n1053 3.75
CS2135 n1052 n1082 3.125
CS2136 n1053 n1054 5
CS2137 n1053 n1083 4.375
CS2138 n1054 n1055 6.25
CS2139 n1054 n1084 5.625
CS2140 n1055 n1056 7.5
CS2141 n1055 n1085 6.875
CS2142 n1056 n1057 8.75
CS2143 n1056 n1086 8.125
CS2144 n1057 n1058 10
CS2145 n1057 n1087 9.375
CS2146 n1058 n1059 11.25
CS2147 n1058 n1088 10.625
CS2148 n1059 n1060 12.5
CS2149 n1059 n1089 11.875
CS2150 n1060 n1061 13.75
CS2151 n1060 n1090 13.125
CS2152 n1061 n1062 15
CS2153 n1061 n1091 14.375
CS2154 n1062 n1063 16.25
CS2155 n1062 n1092 15.625
CS2156 n1063 n1064 17.5
CS2157 n1063 n1093 16.875
CS2158 n1064 n1065 18.75
CS2159 n1064 n1094 18.125
CS2160 n1065 n1066 20
CS2161 n1065 n1095 19.375
CS2162 n1066 n1067 21.25
CS2163 n1066 n1096 20.625
CS2164 n1067 n1068 22.5
CS2165 n1067 n1097 21.875
CS2166 n1068 n1069 23.75
CS2167 n1068 n1098 23.125
CS2168 n1069 n1070 25
CS2169 n1069 n1099 24.375
CS2170 n1070 n1071 26.25
CS2171 n1070 n1100 25.625
CS2172 n1071 n1072 27.5
CS2173 n1071 n1101 26.875
CS2174 n1072 n1073 28.75
CS2175 n1072 n1102 28.125
CS2176 n1073 n1074 30
CS2177 n1073 n1103 29.375
CS2178 n1074 n1075 31.25
CS2179 n1074 n1104 30.625
CS2180 n1075 n1076 32.5
CS2181 n1075 n1105 31.875
CS2182 n1076 n1077 33.75
CS2183 n1076 n1106 33.125
CS2184 n1077 n1078 35
CS2185 n1077 n1107 34.375
CS2186 n1078 n1079 36.25
CS2187 n1078 n1108 35.625
CS2188 n1079 0 37.5
CS2189 n1079 n1109 36.875
CS2190 n1080 n1081 1.25
CS2191 n1080 n1110 0.625
CS2192 n1081 n1082 2.5
CS2193 n1081 n1111 1.875
CS2194 n1082 n1083 3.75
CS2195 n1082 n1112 3.125
CS2196 n1083 n1084 5
CS2197 n1083 n1113 4.375
CS2198 n1084 n1085 6.25
CS2199 n1084 n1114 5.625
CS2200 n1085 n1086 7.5
CS2201 n1085 n1115 6.875
CS2202 n1086 n1087 8.75
CS2203 n1086 n1116 8.125
CS2204 n1087 n1088 10
CS2205 n1087 n1117 9.375
CS2206 n1088 n1089 11.25
CS2207 n1088 n1118 10.625
CS2208 n1089 n1090 12.5
CS2209 n1089 n1119 11.875
CS2210 n1090 n1091 13.75
CS2211 n1090 n1120 13.125
CS2212 n1091 n1092 15
CS2213 n1091 n1121 14.375
CS2214 n1092 n1093 16.25
CS2215 n1092 n1122 15.625
CS2216 n1093 n1094 17.5
CS2217 n1093 n1123 16.875
CS2218 n1094 n1095 18.75
CS2219 n1094 n1124 18.125
CS2220 n1095 n1096 20
CS2221 n1095 n1125 19.375
CS2222 n1096 n1097 21.25
CS2223 n1096 n1126 20.625
CS2224 n1097 n1098 22.5
CS2225 n1097 n1127 21.875
CS2226 n1098 n1099 23.75
CS2227 n1098 n1128 23.125
CS2228 n1099 n1100 25
CS2229 n1099 n1129 24.375
CS2230 n1100 n1101 26.25
CS2231 n1100 n1130 25.625
CS2232 n1101 n1102 27.5
CS2233 n1101 n1131 26.875
CS2234 n1102 n1103 28.75
CS2235 n1102 n1132 28.125
CS2236 n1103 n1104 30
CS2237 n1103 n1133 29.375
CS2238 n1104 n1105 31.25
CS2239 n1104 n1134 30.625
CS2240 n1105 n1106 32.5
CS2241 n1105 n1135 31.875
CS2242 n1106 n1107 33.75
CS2243 n1106 n1136 33.125
CS2244 n1107 n1108 35
CS2245 n1107 n1137 34.375
CS2246 n1108 n1109 36.25
CS2247 n1108 n1138 35.625
CS2248 n1109 0 37.5
CS2249 n1109 n1139 36.875
CS2250 n1110 n1111 1.25
CS2251 n1110 n1140 0.625
CS2252 n1111 n1112 2.5
CS2253 n1111 n1141 1.875
CS2254 n1112 n1113 3.75
CS2255 n1112 n1142 3.125
CS2256 n1113 n1114 5
CS2257 n1113 n1143 4.375
CS2258 n1114 n1115 6.25
CS2259 n1114 n1144 5.625
CS2260 n1115 n1116 7.5
CS2261 n1115 n1145 6.875
CS2262 n1116 n1117 8.75
CS2263 n1116 n1146 8.125
CS2264 n1117 n1118 10
CS2265 n1117 n1147 9.375
CS2266 n1118 n1119 11.25
CS2267 n1118 n1148 10.625
CS2268 n1119 n1120 12.5
CS2269 n1119 n1149 11.875
CS2270 n1120 n1121 13.75
CS2271 n1120 n1150 13.125
CS2272 n1121 n1122 15
CS2273 n1121 n1151 14.375
CS2274 n1122 n1123 16.25
CS2275 n1122 n1152 15.625
CS2276 n1123 n1124 17.5
CS2277 n1123 n1153 16.875
CS2278 n1124 n1125 18.75
CS2279 n1124 n1154 18.125
CS2280 n1125 n1126 20
CS2281 n1125 n1155 19.375
CS2282 n1126 n1127 21.25
CS2283 n1126 n1156 20.625
CS2284 n1127 n1128 22.5
CS2285 n1127 n1157 21.875
CS2286 n1128 n1129 23.75
CS2287 n1128 n1158 23.125
CS2288 n1129 n1130 25
CS2289 n1129 n1159 24.375
CS2290 n1130 n1131 26.25
CS2291 n1130 n1160 25.625
CS2292 n1131 n1132 27.5
CS2293 n1131 n1161 26.875
CS2294 n1132 n1133 28.75
CS2295 n1132 n1162 28.125
CS2296 n1133 n1134 30
CS2297 n1133 n1163 29.375
CS2298 n1134 n1135 31.25
CS2299 n1134 n1164 30.625
CS2300 n1135 n1136 32.5
CS2301 n1135 n1165 31.875
CS2302 n1136 n1137 33.75
CS2303 n1136 n1166 33.125
CS2304 n1137 n1138 35
CS2305 n1137 n1167 34.375
CS2306 n1138 n1139 36.25
CS2307 n1138 n1168 35.625
CS2308 n1139 0 37.5
CS2309 n1139 n1169 36.875
CS2310 n1140 n1141 1.25
CS2311 n1140 n1170 0.625
CS2312 n1141 n1142 2.5
CS2313 n1141 n1171 1.875
CS2314 n1142 n1143 3.75
CS2315 n1142 n1172 3.125
CS2316 n1143 n1144 5
CS2317 n1143 n1173 4.375
CS2318 n1144 n1145 6.25
CS2319 n1144 n1174 5.625
CS2320 n1145 n1146 7.5
CS2321 n1145 n1175 6.875
CS2322 n1146 n1147 8.75
CS2323 n1146 n1176 8.125
CS2324 n1147 n1148 10
CS2325 n1147 n1177 9.375
CS2326 n1148 n1149 11.25
CS2327 n1148 n1178 10.625
CS2328 n1149 n1150 12.5
CS2329 n1149 n1179 11.875
CS2330 n1150 n1151 13.75
CS2331 n1150 n1180 13.125
CS2332 n1151 n1152 15
CS2333 n1151 n1181 14.375
CS2334 n1152 n1153 16.25
CS2335 n1152 n1182 15.625
CS2336 n1153 n1154 17.5
CS2337 n1153 n1183 16.875
CS2338 n1154 n1155 18.75
CS2339 n1154 n1184 18.125
CS2340 n1155 n1156 20
CS2341 n1155 n1185 19.375
CS2342 n1156 n1157 21.25
CS2343 n1156 n1186 20.625
CS2344 n1157 n1158 22.5
CS2345 n1157 n1187 21.875
CS2346 n1158 n1159 23.75
CS2347 n1158 n1188 23.125
CS2348 n1159 n1160 25
CS2349 n1159 n1189 24.375
CS2350 n1160 n1161 26.25
CS2351 n1160 n1190 25.625
CS2352 n1161 n1162 27.5
CS2353 n1161 n1191 26.875
CS2354 n1162 n1163 28.75
CS2355 n1162 n1192 28.125
CS2356 n1163 n1164 30
CS2357 n1163 n1193 29.375
CS2358 n1164 n1165 31.25
CS2359 n1164 n1194 30.625
CS2360 n1165 n1166 32.5
CS2361 n1165 n1195 31.875
CS2362 n1166 n1167 33.75
CS2363 n1166 n1196 33.125
CS2364 n1167 n1168 35
CS2365 n1167 n1197 34.375
CS2366 n1168 n1169 36.25
CS2367 n1168 n1198 35.625
CS2368 n1169 0 37.5
CS2369 n1169 n1199 36.875
CS2370 n1170 n1171 1.25
CS2371 n1170 n1200 0.625
CS2372 n1171 n1172 2.5
CS2373 n1171 n1201 1.875
CS2374 n1172 n1173 3.75
CS2375 n1172 n1202 3.125
CS2376 n1173 n1174 5
CS2377 n1173 n1203 4.375
CS2378 n1174 n1175 6.25
CS2379 n1174 n1204 5.625
CS2380 n1175 n1176 7.5
CS2381 n1175 n1205 6.875
CS2382 n1176 n1177 8.75
CS2383 n1176 n1206 8.125
CS2384 n1177 n1178 10
CS2385 n1177 n1207 9.375
CS2386 n1178 n1179 11.25
CS2387 n1178 n1208 10.625
CS2388 n1179 n1180 12.5
CS2389 n1179 n1209 11.875
CS2390 n1180 n1181 13.75
CS2391 n1180 n1210 13.125
CS2392 n1181 n1182 15
CS2393 n1181 n1211 14.375
CS2394 n1182 n1183 16.25
CS2395 n1182 n1212 15.625
CS2396 n1183 n1184 17.5
CS2397 n1183 n1213 16.875
CS2398 n1184 n1185 18.75
CS2399 n1184 n1214 18.125
CS2400 n1185 n1186 20
CS2401 n1185 n1215 19.375
CS2402 n1186 n1187 21.25
CS2403 n1186 n1216 20.625
CS2404 n1187 n1188 22.5
CS2405 n1187 n1217 21.875
CS2406 n1188 n1189 23.75
CS2407 n1188 n1218 23.125
CS2408 n1189 n1190 25
CS2409 n1189 n1219 24.375
CS2410 n1190 n1191 26.25
CS2411 n1190 n1220 25.625
CS2412 n1191 n1192 27.5
CS2413 n1191 n1221 26.875
CS2414 n1192 n1193 28.75
CS2415 n1192 n1222 28.125
CS2416 n1193 n1194 30
CS2417 n1193 n1223 29.375
CS2418 n1194 n1195 31.25
CS2419 n1194 n1224 30.625
CS2420 n1195 n1196 32.5
CS2421 n1195 n1225 31.875
CS2422 n1196 n1197 33.75
CS2423 n1196 n1226 33.125
CS2424 n1197 n1198 35
CS2425 n1197 n1227 34.375
CS2426 n1198 n1199 36.25
CS2427 n1198 n1228 35.625
CS2428 n1199 0 37.5
CS2429 n1199 n1229 36.875
CS2430 n1200 n1201 1.25
CS2431 n1200 n1230 0.625
CS2432 n1201 n1202 2.5
CS2433 n1201 n1231 1.875
CS2434 n1202 n1203 3.75
CS2435 n1202 n1232 3.125
CS2436 n1203 n1204 5
CS2437 n1203 n1233 4.375
CS2438 n1204 n1205 6.25
CS2439 n1204 n1234 5.625
CS2440 n1205 n1206 7.5
CS2441 n1205 n1235 6.875
CS2442 n1206 n1207 8.75
CS2443 n1206 n1236 8.125
CS2444 n1207 n1208 10
CS2445 n1207 n1237 9.375
CS2446 n1208 n1209 11.25
CS2447 n1208 n1238 10.625
CS2448 n1209 n1210 12.5
CS2449 n1209 n1239 11.875
CS2450 n1210 n1211 13.75
CS2451 n1210 n1240 13.125
CS2452 n1211 n1212 15
CS2453 n1211 n1241 14.375
CS2454 n1212 n1213 16.25
CS2455 n1212 n1242 15.625
CS2456 n1213 n1214 17.5
CS2457 n1213 n1243 16.875
CS2458 n1214 n1215 18.75
CS2459 n1214 n1244 18.125
CS2460 n1215 n1216 20
CS2461 n1215 n1245 19.375
CS2462 n1216 n1217 21.25
CS2463 n1216 n1246 20.625
CS2464 n1217 n1218 22.5
CS2465 n1217 n1247 21.875
CS2466 n1218 n1219 23.75
CS2467 n1218 n1248 23.125
CS2468 n1219 n1220 25
CS2469 n1219 n1249 24.375
CS2470 n1220 n1221 26.25
CS2471 n1220 n1250 25.625
CS2472 n1221 n1222 27.5
CS2473 n1221 n1251 26.875
CS2474 n1222 n1223 28.75
CS2475 n1222 n1252 28.125
CS2476 n1223 n1224 30
CS2477 n1223 n1253 29.375
CS2478 n1224 n1225 31.25
CS2479 n1224 n1254 30.625
CS2480 n1225 n1226 32.5
CS2481 n1225 n1255 31.875
CS2482 n1226 n1227 33.75
CS2483 n1226 n1256 33.125
CS2484 n1227 n1228 35
CS2485 n1227 n1257 34.375
CS2486 n1228 n1229 36.25
CS2487 n1228 n1258 35.625
CS2488 n1229 0 37.5
CS2489 n1229 n1259 36.875
CS2490 n1230 n1231 1.25
CS2491 n1230 n1260 0.625
CS2492 n1231 n1232 2.5
CS2493 n1231 n1261 1.875
CS2494 n1232 n1233 3.75
CS2495 n1232 n1262 3.125
CS2496 n1233 n1234 5
CS2497 n1233 n1263 4.375
CS2498 n1234 n1235 6.25
CS2499 n1234 n1264 5.625
CS2500 n1235 n1236 7.5
CS2501 n1235 n1265 6.875
CS2502 n1236 n1237 8.75
CS2503 n1236 n1266 8.125
CS2504 n1237 n1238 10
CS2505 n1237 n1267 9.375
CS2506 n1238 n1239 11.25
CS2507 n1238 n1268 10.625
CS2508 n1239 n1240 12.5
CS2509 n1239 n1269 11.875
CS2510 n1240 n1241 13.75
CS2511 n1240 n1270 13.125
CS2512 n1241 n1242 15
CS2513 n1241 n1271 14.375
CS2514 n1242 n1243 16.25
CS2515 n1242 n1272 15.625
CS2516 n1243 n1244 17.5
CS2517 n1243 n1273 16.875
CS2518 n1244 n1245 18.75
CS2519 n1244 n1274 18.125
CS2520 n1245 n1246 20
CS2521 n1245 n1275 19.375
CS2522 n1246 n1247 21.25
CS2523 n1246 n1276 20.625
CS2524 n1247 n1248 22.5
CS2525 n1247 n1277 21.875
CS2526 n1248 n1249 23.75
CS2527 n1248 n1278 23.125
CS2528 n1249 n1250 25
CS2529 n1249 n1279 24.375
CS2530 n1250 n1251 26.25
CS2531 n1250 n1280 25.625
CS2532 n1251 n1252 27.5
CS2533 n1251 n1281 26.875
CS2534 n1252 n1253 28.75
CS2535 n1252 n1282 28.125
CS2536 n1253 n1254 30
CS2537 n1253 n1283 29.375
CS2538 n1254 n1255 31.25
CS2539 n1254 n1284 30.625
CS2540 n1255 n1256 32.5
CS2541 n1255 n1285 31.875
CS2542 n1256 n1257 33.75
CS2543 n1256 n1286 33.125
CS2544 n1257 n1258 35
CS2545 n1257 n1287 34.375
CS2546 n1258 n1259 36.25
CS2547 n1258 n1288 35.625
CS2548 n1259 0 37.5
CS2549 n1259 n1289 36.875
CS2550 n1260 n1261 1.25
CS2551 n1260 n1290 0.625
CS2552 n1261 n1262 2.5
CS2553 n1261 n1291 1.875
CS2554 n1262 n1263 3.75
CS2555 n1262 n1292 3.125
CS2556 n1263 n1264 5
CS2557 n1263 n1293 4.375
CS2558 n1264 n1265 6.25
CS2559 n1264 n1294 5.625
CS2560 n1265 n1266 7.5
CS2561 n1265 n1295 6.875
CS2562 n1266 n1267 8.75
CS2563 n1266 n1296 8.125
CS2564 n1267 n1268 10
CS2565 n1267 n1297 9.375
CS2566 n1268 n1269 11.25
CS2567 n1268 n1298 10.625
CS2568 n1269 n1270 12.5
CS2569 n1269 n1299 11.875
CS2570 n1270 n1271 13.75
CS2571 n1270 n1300 13.125
CS2572 n1271 n1272 15
CS2573 n1271 n1301 14.375
CS2574 n1272 n1273 16.25
CS2575 n1272 n1302 15.625
CS2576 n1273 n1274 17.5
CS2577 n1273 n1303 16.875
CS2578 n1274 n1275 18.75
CS2579 n1274 n1304 18.125
CS2580 n1275 n1276 20
CS2581 n1275 n1305 19.375
CS2582 n1276 n1277 21.25
CS2583 n1276 n1306 20.625
CS2584 n1277 n1278 22.5
CS2585 n1277 n1307 21.875
CS2586 n1278 n1279 23.75
CS2587 n1278 n1308 23.125
CS2588 n1279 n1280 25
CS2589 n1279 n1309 24.375
CS2590 n1280 n1281 26.25
CS2591 n1280 n1310 25.625
CS2592 n1281 n1282 27.5
CS2593 n1281 n1311 26.875
CS2594 n1282 n1283 28.75
CS2595 n1282 n1312 28.125
CS2596 n1283 n1284 30
CS2597 n1283 n1313 29.375
CS2598 n1284 n1285 31.25
CS2599 n1284 n1314 30.625
CS2600 n1285 n1286 32.5
CS2601 n1285 n1315 31.875
CS2602 n1286 n1287 33.75
CS2603 n1286 n1316 33.125
CS2604 n1287 n1288 35
CS2605 n1287 n1317 34.375
CS2606 n1288 n1289 36.25
CS2607 n1288 n1318 35.625
CS2608 n1289 0 37.5
CS2609 n1289 n1319 36.875
CS2610 n1290 n1291 1.25
CS2611 n1290 n1320 0.625
CS2612 n1291 n1292 2.5
CS2613 n1291 n1321 1.875
CS2614 n1292 n1293 3.75
CS2615 n1292 n1322 3.125
CS2616 n1293 n1294 5
CS2617 n1293 n1323 4.375
CS2618 n1294 n1295 6.25
CS2619 n1294 n1324 5.625
CS2620 n1295 n1296 7.5
CS2621 n1295 n1325 6.875
CS2622 n1296 n1297 8.75
CS2623 n1296 n1326 8.125
CS2624 n1297 n1298 10
CS2625 n1297 n1327 9.375
CS2626 n1298 n1299 11.25
CS2627 n1298 n1328 10.625
CS2628 n1299 n1300 12.5
CS2629 n1299 n1329 11.875
CS2630 n1300 n1301 13.75
CS2631 n1300 n1330 13.125
CS2632 n1301 n1302 15
CS2633 n1301 n1331 14.375
CS2634 n1302 n1303 16.25
CS2635 n1302 n1332 15.625
CS2636 n1303 n1304 17.5
CS2637 n1303 n1333 16.875
CS2638 n1304 n1305 18.75
CS2639 n1304 n1334 18.125
CS2640 n1305 n1306 20
CS2641 n1305 n1335 19.375
CS2642 n1306 n1307 21.25
CS2643 n1306 n1336 20.625
CS2644 n1307 n1308 22.5
CS2645 n1307 n1337 21.875
CS2646 n1308 n1309 23.75
CS2647 n1308 n1338 23.125
CS2648 n1309 n1310 25
CS2649 n1309 n1339 24.375
CS2650 n1310 n1311 26.25
CS2651 n1310 n1340 25.625
CS2652 n1311 n1312 27.5
CS2653 n1311 n1341 26.875
CS2654 n1312 n1313 28.75
CS2655 n1312 n1342 28.125
CS2656 n1313 n1314 30
CS2657 n1313 n1343 29.375
CS2658 n1314 n1315 31.25
CS2659 n1314 n1344 30.625
CS2660 n1315 n1316 32.5
CS2661 n1315 n1345 31.875
CS2662 n1316 n1317 33.75
CS2663 n1316 n1346 33.125
CS2664 n1317 n1318 35
CS2665 n1317 n1347 34.375
CS2666 n1318 n1319 36.25
CS2667 n1318 n1348 35.625
CS2668 n1319 0 37.5
CS2669 n1319 n1349 36.875
CS2670 n1320 n1321 1.25
CS2671 n1320 n1350 0.625
CS2672 n1321 n1322 2.5
CS2673 n1321 n1351 1.875
CS2674 n1322 n1323 3.75
CS2675 n1322 n1352 3.125
CS2676 n1323 n1324 5
CS2677 n1323 n1353 4.375
CS2678 n1324 n1325 6.25
CS2679 n1324 n1354 5.625
CS2680 n1325 n1326 7.5
CS2681 n1325 n1355 6.875
CS2682 n1326 n1327 8.75
CS2683 n1326 n1356 8.125
CS2684 n1327 n1328 10
CS2685 n1327 n1357 9.375
CS2686 n1328 n1329 11.25
CS2687 n1328 n1358 10.625
CS2688 n1329 n1330 12.5
CS2689 n1329 n1359 11.875
CS2690 n1330 n1331 13.75
CS2691 n1330 n1360 13.125
CS2692 n1331 n1332 15
CS2693 n1331 n1361 14.375
CS2694 n1332 n1333 16.25
CS2695 n1332 n1362 15.625
CS2696 n1333 n1334 17.5
CS2697 n1333 n1363 16.875
CS2698 n1334 n1335 18.75
CS2699 n1334 n1364 18.125
CS2700 n1335 n1336 20
CS2701 n1335 n1365 19.375
CS2702 n1336 n1337 21.25
CS2703 n1336 n1366 20.625
CS2704 n1337 n1338 22.5
CS2705 n1337 n1367 21.875
CS2706 n1338 n1339 23.75
CS2707 n1338 n1368 23.125
CS2708 n1339 n1340 25
CS2709 n1339 n1369 24.375
CS2710 n1340 n1341 26.25
CS2711 n1340 n1370 25.625
CS2712 n1341 n1342 27.5
CS2713 n1341 n1371 26.875
CS2714 n1342 n1343 28.75
CS2715 n1342 n1372 28.125
CS2716 n1343 n1344 30
CS2717 n1343 n1373 29.375
CS2718 n1344 n1345 31.25
CS2719 n1344 n1374 30.625
CS2720 n1345 n1346 32.5
CS2721 n1345 n1375 31.875
CS2722 n1346 n1347 33.75
CS2723 n1346 n1376 33.125
CS2724 n1347 n1348 35
CS2725 n1347 n1377 34.375
CS2726 n1348 n1349 36.25
CS2727 n1348 n1378 35.625
CS2728 n1349 0 37.5
CS2729 n1349 n1379 36.875
CS2730 n1350 n1351 1.25
CS2731 n1350 n1380 0.625
CS2732 n1351 n1352 2.5
CS2733 n1351 n1381 1.875
CS2734 n1352 n1353 3.75
CS2735 n1352 n1382 3.125
CS2736 n1353 n1354 5
CS2737 n1353 n1383 4.375
CS2738 n1354 n1355 6.25
CS2739 n1354 n1384 5.625
CS2740 n1355 n1356 7.5
CS2741 n1355 n1385 6.875
CS2742 n1356 n1357 8.75
CS2743 n1356 n1386 8.125
CS2744 n1357 n1358 10
CS2745 n1357 n1387 9.375
CS2746 n1358 n1359 11.25
CS2747 n1358 n1388 10.625
CS2748 n1359 n1360 12.5
CS2749 n1359 n1389 11.875
CS2750 n1360 n1361 13.75
CS2751 n1360 n1390 13.125
CS2752 n1361 n1362 15
CS2753 n1361 n1391 14.375
CS2754 n1362 n1363 16.25
CS2755 n1362 n1392 15.625
CS2756 n1363 n1364 17.5
CS2757 n1363 n1393 16.875
CS2758 n1364 n1365 18.75
CS2759 n1364 n1394 18.125
CS2760 n1365 n1366 20
CS2761 n1365 n1395 19.375
CS2762 n1366 n1367 21.25
CS2763 n1366 n1396 20.625
CS2764 n1367 n1368 22.5
CS2765 n1367 n1397 21.875
CS2766 n1368 n1369 23.75
CS2767 n1368 n1398 23.125
CS2768 n1369 n1370 25
CS2769 n1369 n1399 24.375
CS2770 n1370 n1371 26.25
CS2771 n1370 n1400 25.625
CS2772 n1371 n1372 27.5
CS2773 n1371 n1401 26.875
CS2774 n1372 n1373 28.75
CS2775 n1372 n1402 28.125
CS2776 n1373 n1374 30
CS2777 n1373 n1403 29.375
CS2778 n1374 n1375 31.25
CS2779 n1374 n1404 30.625
CS2780 n1375 n1376 32.5
CS2781 n1375 n1405 31.875
CS2782 n1376 n1377 33.75
CS2783 n1376 n1406 33.125
CS2784 n1377 n1378 35
CS2785 n1377 n1407 34.375
CS2786 n1378 n1379 36.25
CS2787 n1378 n1408 35.625
CS2788 n1379 0 37.5
CS2789 n1379 n1409 36.875
CS2790 n1380 n1381 1.25
CS2791 n1380 n1410 0.625
CS2792 n1381 n1382 2.5
CS2793 n1381 n1411 1.875
CS2794 n1382 n1383 3.75
CS2795 n1382 n1412 3.125
CS2796 n1383 n1384 5
CS2797 n1383 n1413 4.375
CS2798 n1384 n1385 6.25
CS2799 n1384 n1414 5.625
CS2800 n1385 n1386 7.5
CS2801 n1385 n1415 6.875
CS2802 n1386 n1387 8.75
CS2803 n1386 n1416 8.125
CS2804 n1387 n1388 10
CS2805 n1387 n1417 9.375
CS2806 n1388 n1389 11.25
CS2807 n1388 n1418 10.625
CS2808 n1389 n1390 12.5
CS2809 n1389 n1419 11.875
CS2810 n1390 n1391 13.75
CS2811 n1390 n1420 13.125
CS2812 n1391 n1392 15
CS2813 n1391 n1421 14.375
CS2814 n1392 n1393 16.25
CS2815 n1392 n1422 15.625
CS2816 n1393 n1394 17.5
CS2817 n1393 n1423 16.875
CS2818 n1394 n1395 18.75
CS2819 n1394 n1424 18.125
CS2820 n1395 n1396 20
CS2821 n1395 n1425 19.375
CS2822 n1396 n1397 21.25
CS2823 n1396 n1426 20.625
CS2824 n1397 n1398 22.5
CS2825 n1397 n1427 21.875
CS2826 n1398 n1399 23.75
CS2827 n1398 n1428 23.125
CS2828 n1399 n1400 25
CS2829 n1399 n1429 24.375
CS2830 n1400 n1401 26.25
CS2831 n1400 n1430 25.625
CS2832 n1401 n1402 27.5
CS2833 n1401 n1431 26.875
CS2834 n1402 n1403 28.75
CS2835 n1402 n1432 28.125
CS2836 n1403 n1404 30
CS2837 n1403 n1433 29.375
CS2838 n1404 n1405 31.25
CS2839 n1404 n1434 30.625
CS2840 n1405 n1406 32.5
CS2841 n1405 n1435 31.875
CS2842 n1406 n1407 33.75
CS2843 n1406 n1436 33.125
CS2844 n1407 n1408 35
CS2845 n1407 n1437 34.375
CS2846 n1408 n1409 36.25
CS2847 n1408 n1438 35.625
CS2848 n1409 0 37.5
CS2849 n1409 n1439 36.875
CS2850 n1410 n1411 1.25
CS2851 n1410 n1440 0.625
CS2852 n1411 n1412 2.5
CS2853 n1411 n1441 1.875
CS2854 n1412 n1413 3.75
CS2855 n1412 n1442 3.125
CS2856 n1413 n1414 5
CS2857 n1413 n1443 4.375
CS2858 n1414 n1415 6.25
CS2859 n1414 n1444 5.625
CS2860 n1415 n1416 7.5
CS2861 n1415 n1445 6.875
CS2862 n1416 n1417 8.75
CS2863 n1416 n1446 8.125
CS2864 n1417 n1418 10
CS2865 n1417 n1447 9.375
CS2866 n1418 n1419 11.25
CS2867 n1418 n1448 10.625
CS2868 n1419 n1420 12.5
CS2869 n1419 n1449 11.875
CS2870 n1420 n1421 13.75
CS2871 n1420 n1450 13.125
CS2872 n1421 n1422 15
CS2873 n1421 n1451 14.375
CS2874 n1422 n1423 16.25
CS2875 n1422 n1452 15.625
CS2876 n1423 n1424 17.5
CS2877 n1423 n1453 16.875
CS2878 n1424 n1425 18.75
CS2879 n1424 n1454 18.125
CS2880 n1425 n1426 20
CS2881 n1425 n1455 19.375
CS2882 n1426 n1427 21.25
CS2883 n1426 n1456 20.625
CS2884 n1427 n1428 22.5
CS2885 n1427 n1457 21.875
CS2886 n1428 n1429 23.75
CS2887 n1428 n1458 23.125
CS2888 n1429 n1430 25
CS2889 n1429 n1459 24.375
CS2890 n1430 n1431 26.25
CS2891 n1430 n1460 25.625
CS2892 n1431 n1432 27.5
CS2893 n1431 n1461 26.875
CS2894 n1432 n1433 28.75
CS2895 n1432 n1462 28.125
CS2896 n1433 n1434 30
CS2897 n1433 n1463 29.375
CS2898 n1434 n1435 31.25
CS2899 n1434 n1464 30.625
CS2900 n1435 n1436 32.5
CS2901 n1435 n1465 31.875
CS2902 n1436 n1437 33.75
CS2903 n1436 n1466 33.125
CS2904 n1437 n1438 35
CS2905 n1437 n1467 34.375
CS2906 n1438 n1439 36.25
CS2907 n1438 n1468 35.625
CS2908 n1439 0 37.5
CS2909 n1439 n1469 36.875
CS2910 n1440 n1441 1.25
CS2911 n1440 n1470 0.625
CS2912 n1441 n1442 2.5
CS2913 n1441 n1471 1.875
CS2914 n1442 n1443 3.75
CS2915 n1442 n1472 3.125
CS2916 n1443 n1444 5
CS2917 n1443 n1473 4.375
CS2918 n1444 n1445 6.25
CS2919 n1444 n1474 5.625
CS2920 n1445 n1446 7.5
CS2921 n1445 n1475 6.875
CS2922 n1446 n1447 8.75
CS2923 n1446 n1476 8.125
CS2924 n1447 n1448 10
CS2925 n1447 n1477 9.375
CS2926 n1448 n1449 11.25
CS2927 n1448 n1478 10.625
CS2928 n1449 n1450 12.5
CS2929 n1449 n1479 11.875
CS2930 n1450 n1451 13.75
CS2931 n1450 n1480 13.125
CS2932 n1451 n1452 15
CS2933 n1451 n1481 14.375
CS2934 n1452 n1453 16.25
CS2935 n1452 n1482 15.625
CS2936 n1453 n1454 17.5
CS2937 n1453 n1483 16.875
CS2938 n1454 n1455 18.75
CS2939 n1454 n1484 18.125
CS2940 n1455 n1456 20
CS2941 n1455 n1485 19.375
CS2942 n1456 n1457 21.25
CS2943 n1456 n1486 20.625
CS2944 n1457 n1458 22.5
CS2945 n1457 n1487 21.875
CS2946 n1458 n1459 23.75
CS2947 n1458 n1488 23.125
CS2948 n1459 n1460 25
CS2949 n1459 n1489 24.375
CS2950 n1460 n1461 26.25
CS2951 n1460 n1490 25.625
CS2952 n1461 n1462 27.5
CS2953 n1461 n1491 26.875
CS2954 n1462 n1463 28.75
CS2955 n1462 n1492 28.125
CS2956 n1463 n1464 30
CS2957 n1463 n1493 29.375
CS2958 n1464 n1465 31.25
CS2959 n1464 n1494 30.625
CS2960 n1465 n1466 32.5
CS2961 n1465 n1495 31.875
CS2962 n1466 n1467 33.75
CS2963 n1466 n1496 33.125
CS2964 n1467 n1468 35
CS2965 n1467 n1497 34.375
CS2966 n1468 n1469 36.25
CS2967 n1468 n1498 35.625
CS2968 n1469 0 37.5
CS2969 n1469 n1499 36.875
CS2970 n1470 n1471 1.25
CS2971 n1470 n1500 0.625
CS2972 n1471 n1472 2.5
CS2973 n1471 n1501 1.875
CS2974 n1472 n1473 3.75
CS2975 n1472 n1502 3.125
CS2976 n1473 n1474 5
CS2977 n1473 n1503 4.375
CS2978 n1474 n1475 6.25
CS2979 n1474 n1504 5.625
CS2980 n1475 n1476 7.5
CS2981 n1475 n1505 6.875
CS2982 n1476 n1477 8.75
CS2983 n1476 n1506 8.125
CS2984 n1477 n1478 10
CS2985 n1477 n1507 9.375
CS2986 n1478 n1479 11.25
CS2987 n1478 n1508 10.625
CS2988 n1479 n1480 12.5
CS2989 n1479 n1509 11.875
CS2990 n1480 n1481 13.75
CS2991 n1480 n1510 13.125
CS2992 n1481 n1482 15
CS2993 n1481 n1511 14.375
CS2994 n1482 n1483 16.25
CS2995 n1482 n1512 15.625
CS2996 n1483 n1484 17.5
CS2997 n1483 n1513 16.875
CS2998 n1484 n1485 18.75
CS2999 n1484 n1514 18.125
CS3000 n1485 n1486 20
CS3001 n1485 n1515 19.375
CS3002 n1486 n1487 21.25
CS3003 n1486 n1516 20.625
CS3004 n1487 n1488 22.5
CS3005 n1487 n1517 21.875
CS3006 n1488 n1489 23.75
CS3007 n1488 n1518 23.125
CS3008 n1489 n1490 25
CS3009 n1489 n1519 24.375
CS3010 n1490 n1491 26.25
CS3011 n1490 n1520 25.625
CS3012 n1491 n1492 27.5
CS3013 n1491 n1521 26.875
CS3014 n1492 n1493 28.75
CS3015 n1492 n1522 28.125
CS3016 n1493 n1494 30
CS3017 n1493 n1523 29.375
CS3018 n1494 n1495 31.25
CS3019 n1494 n1524 30.625
CS3020 n1495 n1496 32.5
CS3021 n1495 n1525 31.875
CS3022 n1496 n1497 33.75
CS3023 n1496 n1526 33.125
CS3024 n1497 n1498 35
CS3025 n1497 n1527 34.375
CS3026 n1498 n1499 36.25
CS3027 n1498 n1528 35.625
CS3028 n1499 0 37.5
CS3029 n1499 n1529 36.875
CS3030 n1500 n1501 1.25
CS3031 n1500 n1530 0.625
CS3032 n1501 n1502 2.5
CS3033 n1501 n1531 1.875
CS3034 n1502 n1503 3.75
CS3035 n1502 n1532 3.125
CS3036 n1503 n1504 5
CS3037 n1503 n1533 4.375
CS3038 n1504 n1505 6.25
CS3039 n1504 n1534 5.625
CS3040 n1505 n1506 7.5
CS3041 n1505 n1535 6.875
CS3042 n1506 n1507 8.75
CS3043 n1506 n1536 8.125
CS3044 n1507 n1508 10
CS3045 n1507 n1537 9.375
CS3046 n1508 n1509 11.25
CS3047 n1508 n1538 10.625
CS3048 n1509 n1510 12.5
CS3049 n1509 n1539 11.875
CS3050 n1510 n1511 13.75
CS3051 n1510 n1540 13.125
CS3052 n1511 n1512 15
CS3053 n1511 n1541 14.375
CS3054 n1512 n1513 16.25
CS3055 n1512 n1542 15.625
CS3056 n1513 n1514 17.5
CS3057 n1513 n1543 16.875
CS3058 n1514 n1515 18.75
CS3059 n1514 n1544 18.125
CS3060 n1515 n1516 20
CS3061 n1515 n1545 19.375
CS3062 n1516 n1517 21.25
CS3063 n1516 n1546 20.625
CS3064 n1517 n1518 22.5
CS3065 n1517 n1547 21.875
CS3066 n1518 n1519 23.75
CS3067 n1518 n1548 23.125
CS3068 n1519 n1520 25
CS3069 n1519 n1549 24.375
CS3070 n1520 n1521 26.25
CS3071 n1520 n1550 25.625
CS3072 n1521 n1522 27.5
CS3073 n1521 n1551 26.875
CS3074 n1522 n1523 28.75
CS3075 n1522 n1552 28.125
CS3076 n1523 n1524 30
CS3077 n1523 n1553 29.375
CS3078 n1524 n1525 31.25
CS3079 n1524 n1554 30.625
CS3080 n1525 n1526 32.5
CS3081 n1525 n1555 31.875
CS3082 n1526 n1527 33.75
CS3083 n1526 n1556 33.125
CS3084 n1527 n1528 35
CS3085 n1527 n1557 34.375
CS3086 n1528 n1529 36.25
CS3087 n1528 n1558 35.625
CS3088 n1529 0 37.5
CS3089 n1529 n1559 36.875
CS3090 n1530 n1531 1.25
CS3091 n1530 n1560 0.625
CS3092 n1531 n1532 2.5
CS3093 n1531 n1561 1.875
CS3094 n1532 n1533 3.75
CS3095 n1532 n1562 3.125
CS3096 n1533 n1534 5
CS3097 n1533 n1563 4.375
CS3098 n1534 n1535 6.25
CS3099 n1534 n1564 5.625
CS3100 n1535 n1536 7.5
CS3101 n1535 n1565 6.875
CS3102 n1536 n1537 8.75
CS3103 n1536 n1566 8.125
CS3104 n1537 n1538 10
CS3105 n1537 n1567 9.375
CS3106 n1538 n1539 11.25
CS3107 n1538 n1568 10.625
CS3108 n1539 n1540 12.5
CS3109 n1539 n1569 11.875
CS3110 n1540 n1541 13.75
CS3111 n1540 n1570 13.125
CS3112 n1541 n1542 15
CS3113 n1541 n1571 14.375
CS3114 n1542 n1543 16.25
CS3115 n1542 n1572 15.625
CS3116 n1543 n1544 17.5
CS3117 n1543 n1573 16.875
CS3118 n1544 n1545 18.75
CS3119 n1544 n1574 18.125
CS3120 n1545 n1546 20
CS3121 n1545 n1575 19.375
CS3122 n1546 n1547 21.25
CS3123 n1546 n1576 20.625
CS3124 n1547 n1548 22.5
CS3125 n1547 n1577 21.875
CS3126 n1548 n1549 23.75
CS3127 n1548 n1578 23.125
CS3128 n1549 n1550 25
CS3129 n1549 n1579 24.375
CS3130 n1550 n1551 26.25
CS3131 n1550 n1580 25.625
CS3132 n1551 n1552 27.5
CS3133 n1551 n1581 26.875
CS3134 n1552 n1553 28.75
CS3135 n1552 n1582 28.125
CS3136 n1553 n1554 30
CS3137 n1553 n1583 29.375
CS3138 n1554 n1555 31.25
CS3139 n1554 n1584 30.625
CS3140 n1555 n1556 32.5
CS3141 n1555 n1585 31.875
CS3142 n1556 n1557 33.75
CS3143 n1556 n1586 33.125
CS3144 n1557 n1558 35
CS3145 n1557 n1587 34.375
CS3146 n1558 n1559 36.25
CS3147 n1558 n1588 35.625
CS3148 n1559 0 37.5
CS3149 n1559 n1589 36.875
CS3150 n1560 n1561 1.25
CS3151 n1560 n1590 0.625
CS3152 n1561 n1562 2.5
CS3153 n1561 n1591 1.875
CS3154 n1562 n1563 3.75
CS3155 n1562 n1592 3.125
CS3156 n1563 n1564 5
CS3157 n1563 n1593 4.375
CS3158 n1564 n1565 6.25
CS3159 n1564 n1594 5.625
CS3160 n1565 n1566 7.5
CS3161 n1565 n1595 6.875
CS3162 n1566 n1567 8.75
CS3163 n1566 n1596 8.125
CS3164 n1567 n1568 10
CS3165 n1567 n1597 9.375
CS3166 n1568 n1569 11.25
CS3167 n1568 n1598 10.625
CS3168 n1569 n1570 12.5
CS3169 n1569 n1599 11.875
CS3170 n1570 n1571 13.75
CS3171 n1570 n1600 13.125
CS3172 n1571 n1572 15
CS3173 n1571 n1601 14.375
CS3174 n1572 n1573 16.25
CS3175 n1572 n1602 15.625
CS3176 n1573 n1574 17.5
CS3177 n1573 n1603 16.875
CS3178 n1574 n1575 18.75
CS3179 n1574 n1604 18.125
CS3180 n1575 n1576 20
CS3181 n1575 n1605 19.375
CS3182 n1576 n1577 21.25
CS3183 n1576 n1606 20.625
CS3184 n1577 n1578 22.5
CS3185 n1577 n1607 21.875
CS3186 n1578 n1579 23.75
CS3187 n1578 n1608 23.125
CS3188 n1579 n1580 25
CS3189 n1579 n1609 24.375
CS3190 n1580 n1581 26.25
CS3191 n1580 n1610 25.625
CS3192 n1581 n1582 27.5
CS3193 n1581 n1611 26.875
CS3194 n1582 n1583 28.75
CS3195 n1582 n1612 28.125
CS3196 n1583 n1584 30
CS3197 n1583 n1613 29.375
CS3198 n1584 n1585 31.25
CS3199 n1584 n1614 30.625
CS3200 n1585 n1586 32.5
CS3201 n1585 n1615 31.875
CS3202 n1586 n1587 33.75
CS3203 n1586 n1616 33.125
CS3204 n1587 n1588 35
CS3205 n1587 n1617 34.375
CS3206 n1588 n1589 36.25
CS3207 n1588 n1618 35.625
CS3208 n1589 0 37.5
CS3209 n1589 n1619 36.875
CS3210 n1590 n1591 1.25
CS3211 n1590 n1620 0.625
CS3212 n1591 n1592 2.5
CS3213 n1591 n1621 1.875
CS3214 n1592 n1593 3.75
CS3215 n1592 n1622 3.125
CS3216 n1593 n1594 5
CS3217 n1593 n1623 4.375
CS3218 n1594 n1595 6.25
CS3219 n1594 n1624 5.625
CS3220 n1595 n1596 7.5
CS3221 n1595 n1625 6.875
CS3222 n1596 n1597 8.75
CS3223 n1596 n1626 8.125
CS3224 n1597 n1598 10
CS3225 n1597 n1627 9.375
CS3226 n1598 n1599 11.25
CS3227 n1598 n1628 10.625
CS3228 n1599 n1600 12.5
CS3229 n1599 n1629 11.875
CS3230 n1600 n1601 13.75
CS3231 n1600 n1630 13.125
CS3232 n1601 n1602 15
CS3233 n1601 n1631 14.375
CS3234 n1602 n1603 16.25
CS3235 n1602 n1632 15.625
CS3236 n1603 n1604 17.5
CS3237 n1603 n1633 16.875
CS3238 n1604 n1605 18.75
CS3239 n1604 n1634 18.125
CS3240 n1605 n1606 20
CS3241 n1605 n1635 19.375
CS3242 n1606 n1607 21.25
CS3243 n1606 n1636 20.625
CS3244 n1607 n1608 22.5
CS3245 n1607 n1637 21.875
CS3246 n1608 n1609 23.75
CS3247 n1608 n1638 23.125
CS3248 n1609 n1610 25
CS3249 n1609 n1639 24.375
CS3250 n1610 n1611 26.25
CS3251 n1610 n1640 25.625
CS3252 n1611 n1612 27.5
CS3253 n1611 n1641 26.875
CS3254 n1612 n1613 28.75
CS3255 n1612 n1642 28.125
CS3256 n1613 n1614 30
CS3257 n1613 n1643 29.375
CS3258 n1614 n1615 31.25
CS3259 n1614 n1644 30.625
CS3260 n1615 n1616 32.5
CS3261 n1615 n1645 31.875
CS3262 n1616 n1617 33.75
CS3263 n1616 n1646 33.125
CS3264 n1617 n1618 35
CS3265 n1617 n1647 34.375
CS3266 n1618 n1619 36.25
CS3267 n1618 n1648 35.625
CS3268 n1619 0 37.5
CS3269 n1619 n1649 36.875
CS3270 n1620 n1621 1.25
CS3271 n1620 n1650 0.625
CS3272 n1621 n1622 2.5
CS3273 n1621 n1651 1.875
CS3274 n1622 n1623 3.75
CS3275 n1622 n1652 3.125
CS3276 n1623 n1624 5
CS3277 n1623 n1653 4.375
CS3278 n1624 n1625 6.25
CS3279 n1624 n1654 5.625
CS3280 n1625 n1626 7.5
CS3281 n1625 n1655 6.875
CS3282 n1626 n1627 8.75
CS3283 n1626 n1656 8.125
CS3284 n1627 n1628 10
CS3285 n1627 n1657 9.375
CS3286 n1628 n1629 11.25
CS3287 n1628 n1658 10.625
CS3288 n1629 n1630 12.5
CS3289 n1629 n1659 11.875
CS3290 n1630 n1631 13.75
CS3291 n1630 n1660 13.125
CS3292 n1631 n1632 15
CS3293 n1631 n1661 14.375
CS3294 n1632 n1633 16.25
CS3295 n1632 n1662 15.625
CS3296 n1633 n1634 17.5
CS3297 n1633 n1663 16.875
CS3298 n1634 n1635 18.75
CS3299 n1634 n1664 18.125
CS3300 n1635 n1636 20
CS3301 n1635 n1665 19.375
CS3302 n1636 n1637 21.25
CS3303 n1636 n1666 20.625
CS3304 n1637 n1638 22.5
CS3305 n1637 n1667 21.875
CS3306 n1638 n1639 23.75
CS3307 n1638 n1668 23.125
CS3308 n1639 n1640 25
CS3309 n1639 n1669 24.375
CS3310 n1640 n1641 26.25
CS3311 n1640 n1670 25.625
CS3312 n1641 n1642 27.5
CS3313 n1641 n1671 26.875
CS3314 n1642 n1643 28.75
CS3315 n1642 n1672 28.125
CS3316 n1643 n1644 30
CS3317 n1643 n1673 29.375
CS3318 n1644 n1645 31.25
CS3319 n1644 n1674 30.625
CS3320 n1645 n1646 32.5
CS3321 n1645 n1675 31.875
CS3322 n1646 n1647 33.75
CS3323 n1646 n1676 33.125
CS3324 n1647 n1648 35
CS3325 n1647 n1677 34.375
CS3326 n1648 n1649 36.25
CS3327 n1648 n1678 35.625
CS3328 n1649 0 37.5
CS3329 n1649 n1679 36.875
CS3330 n1650 n1651 1.25
CS3331 n1650 n1680 0.625
CS3332 n1651 n1652 2.5
CS3333 n1651 n1681 1.875
CS3334 n1652 n1653 3.75
CS3335 n1652 n1682 3.125
CS3336 n1653 n1654 5
CS3337 n1653 n1683 4.375
CS3338 n1654 n1655 6.25
CS3339 n1654 n1684 5.625
CS3340 n1655 n1656 7.5
CS3341 n1655 n1685 6.875
CS3342 n1656 n1657 8.75
CS3343 n1656 n1686 8.125
CS3344 n1657 n1658 10
CS3345 n1657 n1687 9.375
CS3346 n1658 n1659 11.25
CS3347 n1658 n1688 10.625
CS3348 n1659 n1660 12.5
CS3349 n1659 n1689 11.875
CS3350 n1660 n1661 13.75
CS3351 n1660 n1690 13.125
CS3352 n1661 n1662 15
CS3353 n1661 n1691 14.375
CS3354 n1662 n1663 16.25
CS3355 n1662 n1692 15.625
CS3356 n1663 n1664 17.5
CS3357 n1663 n1693 16.875
CS3358 n1664 n1665 18.75
CS3359 n1664 n1694 18.125
CS3360 n1665 n1666 20
CS3361 n1665 n1695 19.375
CS3362 n1666 n1667 21.25
CS3363 n1666 n1696 20.625
CS3364 n1667 n1668 22.5
CS3365 n1667 n1697 21.875
CS3366 n1668 n1669 23.75
CS3367 n1668 n1698 23.125
CS3368 n1669 n1670 25
CS3369 n1669 n1699 24.375
CS3370 n1670 n1671 26.25
CS3371 n1670 n1700 25.625
CS3372 n1671 n1672 27.5
CS3373 n1671 n1701 26.875
CS3374 n1672 n1673 28.75
CS3375 n1672 n1702 28.125
CS3376 n1673 n1674 30
CS3377 n1673 n1703 29.375
CS3378 n1674 n1675 31.25
CS3379 n1674 n1704 30.625
CS3380 n1675 n1676 32.5
CS3381 n1675 n1705 31.875
CS3382 n1676 n1677 33.75
CS3383 n1676 n1706 33.125
CS3384 n1677 n1678 35
CS3385 n1677 n1707 34.375
CS3386 n1678 n1679 36.25
CS3387 n1678 n1708 35.625
CS3388 n1679 0 37.5
CS3389 n1679 n1709 36.875
CS3390 n1680 n1681 1.25
CS3391 n1680 n1710 0.625
CS3392 n1681 n1682 2.5
CS3393 n1681 n1711 1.875
CS3394 n1682 n1683 3.75
CS3395 n1682 n1712 3.125
CS3396 n1683 n1684 5
CS3397 n1683 n1713 4.375
CS3398 n1684 n1685 6.25
CS3399 n1684 n1714 5.625
CS3400 n1685 n1686 7.5
CS3401 n1685 n1715 6.875
CS3402 n1686 n1687 8.75
CS3403 n1686 n1716 8.125
CS3404 n1687 n1688 10
CS3405 n1687 n1717 9.375
CS3406 n1688 n1689 11.25
CS3407 n1688 n1718 10.625
CS3408 n1689 n1690 12.5
CS3409 n1689 n1719 11.875
CS3410 n1690 n1691 13.75
CS3411 n1690 n1720 13.125
CS3412 n1691 n1692 15
CS3413 n1691 n1721 14.375
CS3414 n1692 n1693 16.25
CS3415 n1692 n1722 15.625
CS3416 n1693 n1694 17.5
CS3417 n1693 n1723 16.875
CS3418 n1694 n1695 18.75
CS3419 n1694 n1724 18.125
CS3420 n1695 n1696 20
CS3421 n1695 n1725 19.375
CS3422 n1696 n1697 21.25
CS3423 n1696 n1726 20.625
CS3424 n1697 n1698 22.5
CS3425 n1697 n1727 21.875
CS3426 n1698 n1699 23.75
CS3427 n1698 n1728 23.125
CS3428 n1699 n1700 25
CS3429 n1699 n1729 24.375
CS3430 n1700 n1701 26.25
CS3431 n1700 n1730 25.625
CS3432 n1701 n1702 27.5
CS3433 n1701 n1731 26.875
CS3434 n1702 n1703 28.75
CS3435 n1702 n1732 28.125
CS3436 n1703 n1704 30
CS3437 n1703 n1733 29.375
CS3438 n1704 n1705 31.25
CS3439 n1704 n1734 30.625
CS3440 n1705 n1706 32.5
CS3441 n1705 n1735 31.875
CS3442 n1706 n1707 33.75
CS3443 n1706 n1736 33.125
CS3444 n1707 n1708 35
CS3445 n1707 n1737 34.375
CS3446 n1708 n1709 36.25
CS3447 n1708 n1738 35.625
CS3448 n1709 0 37.5
CS3449 n1709 n1739 36.875
CS3450 n1710 n1711 1.25
CS3451 n1710 n1740 0.625
CS3452 n1711 n1712 2.5
CS3453 n1711 n1741 1.875
CS3454 n1712 n1713 3.75
CS3455 n1712 n1742 3.125
CS3456 n1713 n1714 5
CS3457 n1713 n1743 4.375
CS3458 n1714 n1715 6.25
CS3459 n1714 n1744 5.625
CS3460 n1715 n1716 7.5
CS3461 n1715 n1745 6.875
CS3462 n1716 n1717 8.75
CS3463 n1716 n1746 8.125
CS3464 n1717 n1718 10
CS3465 n1717 n1747 9.375
CS3466 n1718 n1719 11.25
CS3467 n1718 n1748 10.625
CS3468 n1719 n1720 12.5
CS3469 n1719 n1749 11.875
CS3470 n1720 n1721 13.75
CS3471 n1720 n1750 13.125
CS3472 n1721 n1722 15
CS3473 n1721 n1751 14.375
CS3474 n1722 n1723 16.25
CS3475 n1722 n1752 15.625
CS3476 n1723 n1724 17.5
CS3477 n1723 n1753 16.875
CS3478 n1724 n1725 18.75
CS3479 n1724 n1754 18.125
CS3480 n1725 n1726 20
CS3481 n1725 n1755 19.375
CS3482 n1726 n1727 21.25
CS3483 n1726 n1756 20.625
CS3484 n1727 n1728 22.5
CS3485 n1727 n1757 21.875
CS3486 n1728 n1729 23.75
CS3487 n1728 n1758 23.125
CS3488 n1729 n1730 25
CS3489 n1729 n1759 24.375
CS3490 n1730 n1731 26.25
CS3491 n1730 n1760 25.625
CS3492 n1731 n1732 27.5
CS3493 n1731 n1761 26.875
CS3494 n1732 n1733 28.75
CS3495 n1732 n1762 28.125
CS3496 n1733 n1734 30
CS3497 n1733 n1763 29.375
CS3498 n1734 n1735 31.25
CS3499 n1734 n1764 30.625
CS3500 n1735 n1736 32.5
CS3501 n1735 n1765 31.875
CS3502 n1736 n1737 33.75
CS3503 n1736 n1766 33.125
CS3504 n1737 n1738 35
CS3505 n1737 n1767 34.375
CS3506 n1738 n1739 36.25
CS3507 n1738 n1768 35.625
CS3508 n1739 0 37.5
CS3509 n1739 n1769 36.875
CS3510 n1740 n1741 1.25
CS3511 n1740 n1770 0.625
CS3512 n1741 n1742 2.5
CS3513 n1741 n1771 1.875
CS3514 n1742 n1743 3.75
CS3515 n1742 n1772 3.125
CS3516 n1743 n1744 5
CS3517 n1743 n1773 4.375
CS3518 n1744 n1745 6.25
CS3519 n1744 n1774 5.625
CS3520 n1745 n1746 7.5
CS3521 n1745 n1775 6.875
CS3522 n1746 n1747 8.75
CS3523 n1746 n1776 8.125
CS3524 n1747 n1748 10
CS3525 n1747 n1777 9.375
CS3526 n1748 n1749 11.25
CS3527 n1748 n1778 10.625
CS3528 n1749 n1750 12.5
CS3529 n1749 n1779 11.875
CS3530 n1750 n1751 13.75
CS3531 n1750 n1780 13.125
CS3532 n1751 n1752 15
CS3533 n1751 n1781 14.375
CS3534 n1752 n1753 16.25
CS3535 n1752 n1782 15.625
CS3536 n1753 n1754 17.5
CS3537 n1753 n1783 16.875
CS3538 n1754 n1755 18.75
CS3539 n1754 n1784 18.125
CS3540 n1755 n1756 20
CS3541 n1755 n1785 19.375
CS3542 n1756 n1757 21.25
CS3543 n1756 n1786 20.625
CS3544 n1757 n1758 22.5
CS3545 n1757 n1787 21.875
CS3546 n1758 n1759 23.75
CS3547 n1758 n1788 23.125
CS3548 n1759 n1760 25
CS3549 n1759 n1789 24.375
CS3550 n1760 n1761 26.25
CS3551 n1760 n1790 25.625
CS3552 n1761 n1762 27.5
CS3553 n1761 n1791 26.875
CS3554 n1762 n1763 28.75
CS3555 n1762 n1792 28.125
CS3556 n1763 n1764 30
CS3557 n1763 n1793 29.375
CS3558 n1764 n1765 31.25
CS3559 n1764 n1794 30.625
CS3560 n1765 n1766 32.5
CS3561 n1765 n1795 31.875
CS3562 n1766 n1767 33.75
CS3563 n1766 n1796 33.125
CS3564 n1767 n1768 35
CS3565 n1767 n1797 34.375
CS3566 n1768 n1769 36.25
CS3567 n1768 n1798 35.625
CS3568 n1769 0 37.5
CS3569 n1769 n1799 36.875
CS3570 n1770 n1771 1.25
CS3571 n1770 n1800 0.625
CS3572 n1771 n1772 2.5
CS3573 n1771 n1801 1.875
CS3574 n1772 n1773 3.75
CS3575 n1772 n1802 3.125
CS3576 n1773 n1774 5
CS3577 n1773 n1803 4.375
CS3578 n1774 n1775 6.25
CS3579 n1774 n1804 5.625
CS3580 n1775 n1776 7.5
CS3581 n1775 n1805 6.875
CS3582 n1776 n1777 8.75
CS3583 n1776 n1806 8.125
CS3584 n1777 n1778 10
CS3585 n1777 n1807 9.375
CS3586 n1778 n1779 11.25
CS3587 n1778 n1808 10.625
CS3588 n1779 n1780 12.5
CS3589 n1779 n1809 11.875
CS3590 n1780 n1781 13.75
CS3591 n1780 n1810 13.125
CS3592 n1781 n1782 15
CS3593 n1781 n1811 14.375
CS3594 n1782 n1783 16.25
CS3595 n1782 n1812 15.625
CS3596 n1783 n1784 17.5
CS3597 n1783 n1813 16.875
CS3598 n1784 n1785 18.75
CS3599 n1784 n1814 18.125
CS3600 n1785 n1786 20
CS3601 n1785 n1815 19.375
CS3602 n1786 n1787 21.25
CS3603 n1786 n1816 20.625
CS3604 n1787 n1788 22.5
CS3605 n1787 n1817 21.875
CS3606 n1788 n1789 23.75
CS3607 n1788 n1818 23.125
CS3608 n1789 n1790 25
CS3609 n1789 n1819 24.375
CS3610 n1790 n1791 26.25
CS3611 n1790 n1820 25.625
CS3612 n1791 n1792 27.5
CS3613 n1791 n1821 26.875
CS3614 n1792 n1793 28.75
CS3615 n1792 n1822 28.125
CS3616 n1793 n1794 30
CS3617 n1793 n1823 29.375
CS3618 n1794 n1795 31.25
CS3619 n1794 n1824 30.625
CS3620 n1795 n1796 32.5
CS3621 n1795 n1825 31.875
CS3622 n1796 n1797 33.75
CS3623 n1796 n1826 33.125
CS3624 n1797 n1798 35
CS3625 n1797 n1827 34.375
CS3626 n1798 n1799 36.25
CS3627 n1798 n1828 35.625
CS3628 n1799 0 37.5
CS3629 n1799 n1829 36.875
CS3630 n1800 n1801 1.25
CS3631 n1800 n1830 0.625
CS3632 n1801 n1802 2.5
CS3633 n1801 n1831 1.875
CS3634 n1802 n1803 3.75
CS3635 n1802 n1832 3.125
CS3636 n1803 n1804 5
CS3637 n1803 n1833 4.375
CS3638 n1804 n1805 6.25
CS3639 n1804 n1834 5.625
CS3640 n1805 n1806 7.5
CS3641 n1805 n1835 6.875
CS3642 n1806 n1807 8.75
CS3643 n1806 n1836 8.125
CS3644 n1807 n1808 10
CS3645 n1807 n1837 9.375
CS3646 n1808 n1809 11.25
CS3647 n1808 n1838 10.625
CS3648 n1809 n1810 12.5
CS3649 n1809 n1839 11.875
CS3650 n1810 n1811 13.75
CS3651 n1810 n1840 13.125
CS3652 n1811 n1812 15
CS3653 n1811 n1841 14.375
CS3654 n1812 n1813 16.25
CS3655 n1812 n1842 15.625
CS3656 n1813 n1814 17.5
CS3657 n1813 n1843 16.875
CS3658 n1814 n1815 18.75
CS3659 n1814 n1844 18.125
CS3660 n1815 n1816 20
CS3661 n1815 n1845 19.375
CS3662 n1816 n1817 21.25
CS3663 n1816 n1846 20.625
CS3664 n1817 n1818 22.5
CS3665 n1817 n1847 21.875
CS3666 n1818 n1819 23.75
CS3667 n1818 n1848 23.125
CS3668 n1819 n1820 25
CS3669 n1819 n1849 24.375
CS3670 n1820 n1821 26.25
CS3671 n1820 n1850 25.625
CS3672 n1821 n1822 27.5
CS3673 n1821 n1851 26.875
CS3674 n1822 n1823 28.75
CS3675 n1822 n1852 28.125
CS3676 n1823 n1824 30
CS3677 n1823 n1853 29.375
CS3678 n1824 n1825 31.25
CS3679 n1824 n1854 30.625
CS3680 n1825 n1826 32.5
CS3681 n1825 n1855 31.875
CS3682 n1826 n1827 33.75
CS3683 n1826 n1856 33.125
CS3684 n1827 n1828 35
CS3685 n1827 n1857 34.375
CS3686 n1828 n1829 36.25
CS3687 n1828 n1858 35.625
CS3688 n1829 0 37.5
CS3689 n1829 n1859 36.875
CS3690 n1830 n1831 1.25
CS3691 n1830 n1860 0.625
CS3692 n1831 n1832 2.5
CS3693 n1831 n1861 1.875
CS3694 n1832 n1833 3.75
CS3695 n1832 n1862 3.125
CS3696 n1833 n1834 5
CS3697 n1833 n1863 4.375
CS3698 n1834 n1835 6.25
CS3699 n1834 n1864 5.625
CS3700 n1835 n1836 7.5
CS3701 n1835 n1865 6.875
CS3702 n1836 n1837 8.75
CS3703 n1836 n1866 8.125
CS3704 n1837 n1838 10
CS3705 n1837 n1867 9.375
CS3706 n1838 n1839 11.25
CS3707 n1838 n1868 10.625
CS3708 n1839 n1840 12.5
CS3709 n1839 n1869 11.875
CS3710 n1840 n1841 13.75
CS3711 n1840 n1870 13.125
CS3712 n1841 n1842 15
CS3713 n1841 n1871 14.375
CS3714 n1842 n1843 16.25
CS3715 n1842 n1872 15.625
CS3716 n1843 n1844 17.5
CS3717 n1843 n1873 16.875
CS3718 n1844 n1845 18.75
CS3719 n1844 n1874 18.125
CS3720 n1845 n1846 20
CS3721 n1845 n1875 19.375
CS3722 n1846 n1847 21.25
CS3723 n1846 n1876 20.625
CS3724 n1847 n1848 22.5
CS3725 n1847 n1877 21.875
CS3726 n1848 n1849 23.75
CS3727 n1848 n1878 23.125
CS3728 n1849 n1850 25
CS3729 n1849 n1879 24.375
CS3730 n1850 n1851 26.25
CS3731 n1850 n1880 25.625
CS3732 n1851 n1852 27.5
CS3733 n1851 n1881 26.875
CS3734 n1852 n1853 28.75
CS3735 n1852 n1882 28.125
CS3736 n1853 n1854 30
CS3737 n1853 n1883 29.375
CS3738 n1854 n1855 31.25
CS3739 n1854 n1884 30.625
CS3740 n1855 n1856 32.5
CS3741 n1855 n1885 31.875
CS3742 n1856 n1857 33.75
CS3743 n1856 n1886 33.125
CS3744 n1857 n1858 35
CS3745 n1857 n1887 34.375
CS3746 n1858 n1859 36.25
CS3747 n1858 n1888 35.625
CS3748 n1859 0 37.5
CS3749 n1859 n1889 36.875
CS3750 n1860 n1861 1.25
CS3751 n1860 n1890 0.625
CS3752 n1861 n1862 2.5
CS3753 n1861 n1891 1.875
CS3754 n1862 n1863 3.75
CS3755 n1862 n1892 3.125
CS3756 n1863 n1864 5
CS3757 n1863 n1893 4.375
CS3758 n1864 n1865 6.25
CS3759 n1864 n1894 5.625
CS3760 n1865 n1866 7.5
CS3761 n1865 n1895 6.875
CS3762 n1866 n1867 8.75
CS3763 n1866 n1896 8.125
CS3764 n1867 n1868 10
CS3765 n1867 n1897 9.375
CS3766 n1868 n1869 11.25
CS3767 n1868 n1898 10.625
CS3768 n1869 n1870 12.5
CS3769 n1869 n1899 11.875
CS3770 n1870 n1871 13.75
CS3771 n1870 n1900 13.125
CS3772 n1871 n1872 15
CS3773 n1871 n1901 14.375
CS3774 n1872 n1873 16.25
CS3775 n1872 n1902 15.625
CS3776 n1873 n1874 17.5
CS3777 n1873 n1903 16.875
CS3778 n1874 n1875 18.75
CS3779 n1874 n1904 18.125
CS3780 n1875 n1876 20
CS3781 n1875 n1905 19.375
CS3782 n1876 n1877 21.25
CS3783 n1876 n1906 20.625
CS3784 n1877 n1878 22.5
CS3785 n1877 n1907 21.875
CS3786 n1878 n1879 23.75
CS3787 n1878 n1908 23.125
CS3788 n1879 n1880 25
CS3789 n1879 n1909 24.375
CS3790 n1880 n1881 26.25
CS3791 n1880 n1910 25.625
CS3792 n1881 n1882 27.5
CS3793 n1881 n1911 26.875
CS3794 n1882 n1883 28.75
CS3795 n1882 n1912 28.125
CS3796 n1883 n1884 30
CS3797 n1883 n1913 29.375
CS3798 n1884 n1885 31.25
CS3799 n1884 n1914 30.625
CS3800 n1885 n1886 32.5
CS3801 n1885 n1915 31.875
CS3802 n1886 n1887 33.75
CS3803 n1886 n1916 33.125
CS3804 n1887 n1888 35
CS3805 n1887 n1917 34.375
CS3806 n1888 n1889 36.25
CS3807 n1888 n1918 35.625
CS3808 n1889 0 37.5
CS3809 n1889 n1919 36.875
CS3810 n1890 n1891 1.25
CS3811 n1890 n1920 0.625
CS3812 n1891 n1892 2.5
CS3813 n1891 n1921 1.875
CS3814 n1892 n1893 3.75
CS3815 n1892 n1922 3.125
CS3816 n1893 n1894 5
CS3817 n1893 n1923 4.375
CS3818 n1894 n1895 6.25
CS3819 n1894 n1924 5.625
CS3820 n1895 n1896 7.5
CS3821 n1895 n1925 6.875
CS3822 n1896 n1897 8.75
CS3823 n1896 n1926 8.125
CS3824 n1897 n1898 10
CS3825 n1897 n1927 9.375
CS3826 n1898 n1899 11.25
CS3827 n1898 n1928 10.625
CS3828 n1899 n1900 12.5
CS3829 n1899 n1929 11.875
CS3830 n1900 n1901 13.75
CS3831 n1900 n1930 13.125
CS3832 n1901 n1902 15
CS3833 n1901 n1931 14.375
CS3834 n1902 n1903 16.25
CS3835 n1902 n1932 15.625
CS3836 n1903 n1904 17.5
CS3837 n1903 n1933 16.875
CS3838 n1904 n1905 18.75
CS3839 n1904 n1934 18.125
CS3840 n1905 n1906 20
CS3841 n1905 n1935 19.375
CS3842 n1906 n1907 21.25
CS3843 n1906 n1936 20.625
CS3844 n1907 n1908 22.5
CS3845 n1907 n1937 21.875
CS3846 n1908 n1909 23.75
CS3847 n1908 n1938 23.125
CS3848 n1909 n1910 25
CS3849 n1909 n1939 24.375
CS3850 n1910 n1911 26.25
CS3851 n1910 n1940 25.625
CS3852 n1911 n1912 27.5
CS3853 n1911 n1941 26.875
CS3854 n1912 n1913 28.75
CS3855 n1912 n1942 28.125
CS3856 n1913 n1914 30
CS3857 n1913 n1943 29.375
CS3858 n1914 n1915 31.25
CS3859 n1914 n1944 30.625
CS3860 n1915 n1916 32.5
CS3861 n1915 n1945 31.875
CS3862 n1916 n1917 33.75
CS3863 n1916 n1946 33.125
CS3864 n1917 n1918 35
CS3865 n1917 n1947 34.375
CS3866 n1918 n1919 36.25
CS3867 n1918 n1948 35.625
CS3868 n1919 0 37.5
CS3869 n1919 n1949 36.875
CS3870 n1920 n1921 1.25
CS3871 n1920 0 0.625
CS3872 n1921 n1922 2.5
CS3873 n1921 0 1.875
CS3874 n1922 n1923 3.75
CS3875 n1922 0 3.125
CS3876 n1923 n1924 5
CS3877 n1923 0 4.375
CS3878 n1924 n1925 6.25
CS3879 n1924 0 5.625
CS3880 n1925 n1926 7.5
CS3881 n1925 0 6.875
CS3882 n1926 n1927 8.75
CS3883 n1926 0 8.125
CS3884 n1927 n1928 10
CS3885 n1927 0 9.375
CS3886 n1928 n1929 11.25
CS3887 n1928 0 10.625
CS3888 n1929 n1930 12.5
CS3889 n1929 0 11.875
CS3890 n1930 n1931 13.75
CS3891 n1930 0 13.125
CS3892 n1931 n1932 15
CS3893 n1931 0 14.375
CS3894 n1932 n1933 16.25
CS3895 n1932 0 15.625
CS3896 n1933 n1934 17.5
CS3897 n1933 0 16.875
CS3898 n1934 n1935 18.75
CS3899 n1934 0 18.125
CS3900 n1935 n1936 20
CS3901 n1935 0 19.375
CS3902 n1936 n1937 21.25
CS3903 n1936 0 20.625
CS3904 n1937 n1938 22.5
CS3905 n1937 0 21.875
CS3906 n1938 n1939 23.75
CS3907 n1938 0 23.125
CS3908 n1939 n1940 25
CS3909 n1939 0 24.375
CS3910 n1940 n1941 26.25
CS3911 n1940 0 25.625
CS3912 n1941 n1942 27.5
CS3913 n1941 0 26.875
CS3914 n1942 n1943 28.75
CS3915 n1942 0 28.125
CS3916 n1943 n1944 30
CS3917 n1943 0 29.375
CS3918 n1944 n1945 31.25
CS3919 n1944 0 30.625
CS3920 n1945 n1946 32.5
CS3921 n1945 0 31.875
CS3922 n1946 n1947 33.75
CS3923 n1946 0 33.125
CS3924 n1947 n1948 35
CS3925 n1947 0 34.375
CS3926 n1948 n1949 36.25
CS3927 n1948 0 35.625
CS3928 n1949 0 37.5
CS3929 n1949 0 36.875
I1 0 n960 AC 1
.ac lin 241 0.072737279 0.084025786
.end
