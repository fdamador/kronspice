Marx generator charging, 4 stages, Ar gaps
VS s 0 PULSE(0 9634.54 0 1u 1u 1 2)
RS s h1 1e+06
C1 h1 0 1e-08
RH1 h1 h2 100000
RL1 0 l2 100000
C2 h2 l2 1e-08
RH2 h2 h3 100000
RL2 l2 l3 100000
C3 h3 l3 1e-08
RH3 h3 h4 100000
RL3 l3 l4 100000
C4 h4 l4 1e-08
.tran 0.00128 0.512
.end
