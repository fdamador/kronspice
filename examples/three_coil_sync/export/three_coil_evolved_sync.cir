three coils: HV coil 1 wired to resonant coil 3, Royer coil 2 wound over coil 3
.model dfast D(IS=1e-09 N=1.5 RS=0.1)
.model npwr NMOS(KP=30 LAMBDA=0.001 LEVEL=1 RD=0.02 RS=0.005 VTO=4)
Es s 0 c1 c2 1
Rsb s 0 1e+06
Rph s lag 12231.092687096268
Cph lag 0 1e-09
Rh1 s half 100000
Rh2 half 0 100000
Eg hvg 0 lag half -0.3341848839098054
Rg hvg hvp 1
R1p hvp p1 0.011070894060304617
L1p p1 0 2.6861341241812957e-06
L1s hv s1 0.0002495337165338145
R1s s1 0 1.6211
C1self hv 0 4.583293682304969e-12
K1 L1p L1s 0.5423276762550369
L3 hv a3 0.00038070348292018537
R3 a3 b3 0.6456191999999998
C3 b3 out 1.5e-07
RL out 0 24
Vcc vcc 0 PULSE(0 24 0 2e-05 2e-05 1 2)
Vgate v12 0 PULSE(0 12 0 2e-05 2e-05 1 2)
Rs vcc v1 0.03
Lchoke v1 ct 0.0001
L2a c1 a2 4.385557896451867e-06
R2a a2 ct 0.015967232056923287
L2b ct b2 4.385557896451867e-06
R2b b2 c2 0.015967232056923287
RC2 c1 t2 0.005
C2 t2 c2 4.7e-06
M1 c1 g1 0 0 npwr
M2 c2 g2 0 0 npwr
RG1 v12 g1 470
RG2 v12 g2 479.4
CG1 g1 0 3e-09
CG2 g2 0 3e-09
COSS1 c1 0 1e-09
COSS2 c2 0 1e-09
D1 g1 c2 dfast
D2 g2 c1 dfast
K2ab L2a L2b 0.9649683594427817
K2a3 L2a L3 0.43316477336132675
K2b3 L2b L3 0.4331512987734506
.tran 2e-07 0.0025 0 2e-07
.end
