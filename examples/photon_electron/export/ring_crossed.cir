crossed two-wire ring
LA0 a0 ma0 1e-06
RA0 ma0 a1 0.01
LB0 b0 mb0 1e-06
RB0 mb0 b1 0.01
CD0 a0 b0 1e-09
CGA0 a0 0 1e-10
CGB0 b0 0 1e-10
LA1 a1 ma1 1e-06
RA1 ma1 a2 0.01
LB1 b1 mb1 1e-06
RB1 mb1 b2 0.01
CD1 a1 b1 1e-09
CGA1 a1 0 1e-10
CGB1 b1 0 1e-10
LA2 a2 ma2 1e-06
RA2 ma2 a3 0.01
LB2 b2 mb2 1e-06
RB2 mb2 b3 0.01
CD2 a2 b2 1e-09
CGA2 a2 0 1e-10
CGB2 b2 0 1e-10
LA3 a3 ma3 1e-06
RA3 ma3 a4 0.01
LB3 b3 mb3 1e-06
RB3 mb3 b4 0.01
CD3 a3 b3 1e-09
CGA3 a3 0 1e-10
CGB3 b3 0 1e-10
LA4 a4 ma4 1e-06
RA4 ma4 a5 0.01
LB4 b4 mb4 1e-06
RB4 mb4 b5 0.01
CD4 a4 b4 1e-09
CGA4 a4 0 1e-10
CGB4 b4 0 1e-10
LA5 a5 ma5 1e-06
RA5 ma5 a6 0.01
LB5 b5 mb5 1e-06
RB5 mb5 b6 0.01
CD5 a5 b5 1e-09
CGA5 a5 0 1e-10
CGB5 b5 0 1e-10
LA6 a6 ma6 1e-06
RA6 ma6 a7 0.01
LB6 b6 mb6 1e-06
RB6 mb6 b7 0.01
CD6 a6 b6 1e-09
CGA6 a6 0 1e-10
CGB6 b6 0 1e-10
LA7 a7 ma7 1e-06
RA7 ma7 a8 0.01
LB7 b7 mb7 1e-06
RB7 mb7 b8 0.01
CD7 a7 b7 1e-09
CGA7 a7 0 1e-10
CGB7 b7 0 1e-10
LA8 a8 ma8 1e-06
RA8 ma8 a9 0.01
LB8 b8 mb8 1e-06
RB8 mb8 b9 0.01
CD8 a8 b8 1e-09
CGA8 a8 0 1e-10
CGB8 b8 0 1e-10
LA9 a9 ma9 1e-06
RA9 ma9 a10 0.01
LB9 b9 mb9 1e-06
RB9 mb9 b10 0.01
CD9 a9 b9 1e-09
CGA9 a9 0 1e-10
CGB9 b9 0 1e-10
LA10 a10 ma10 1e-06
RA10 ma10 a11 0.01
LB10 b10 mb10 1e-06
RB10 mb10 b11 0.01
CD10 a10 b10 1e-09
CGA10 a10 0 1e-10
CGB10 b10 0 1e-10
LA11 a11 ma11 1e-06
RA11 ma11 a12 0.01
LB11 b11 mb11 1e-06
RB11 mb11 b12 0.01
CD11 a11 b11 1e-09
CGA11 a11 0 1e-10
CGB11 b11 0 1e-10
LA12 a12 ma12 1e-06
RA12 ma12 a13 0.01
LB12 b12 mb12 1e-06
RB12 mb12 b13 0.01
CD12 a12 b12 1e-09
CGA12 a12 0 1e-10
CGB12 b12 0 1e-10
LA13 a13 ma13 1e-06
RA13 ma13 a14 0.01
LB13 b13 mb13 1e-06
RB13 mb13 b14 0.01
CD13 a13 b13 1e-09
CGA13 a13 0 1e-10
CGB13 b13 0 1e-10
LA14 a14 ma14 1e-06
RA14 ma14 a15 0.01
LB14 b14 mb14 1e-06
RB14 mb14 b15 0.01
CD14 a14 b14 1e-09
CGA14 a14 0 1e-10
CGB14 b14 0 1e-10
LA15 a15 ma15 1e-06
RA15 ma15 a16 0.01
LB15 b15 mb15 1e-06
RB15 mb15 b16 0.01
CD15 a15 b15 1e-09
CGA15 a15 0 1e-10
CGB15 b15 0 1e-10
LA16 a16 ma16 1e-06
RA16 ma16 a17 0.01
LB16 b16 mb16 1e-06
RB16 mb16 b17 0.01
CD16 a16 b16 1e-09
CGA16 a16 0 1e-10
CGB16 b16 0 1e-10
LA17 a17 ma17 1e-06
RA17 ma17 a18 0.01
LB17 b17 mb17 1e-06
RB17 mb17 b18 0.01
CD17 a17 b17 1e-09
CGA17 a17 0 1e-10
CGB17 b17 0 1e-10
LA18 a18 ma18 1e-06
RA18 ma18 a19 0.01
LB18 b18 mb18 1e-06
RB18 mb18 b19 0.01
CD18 a18 b18 1e-09
CGA18 a18 0 1e-10
CGB18 b18 0 1e-10
LA19 a19 ma19 1e-06
RA19 ma19 a20 0.01
LB19 b19 mb19 1e-06
RB19 mb19 b20 0.01
CD19 a19 b19 1e-09
CGA19 a19 0 1e-10
CGB19 b19 0 1e-10
LA20 a20 ma20 1e-06
RA20 ma20 a21 0.01
LB20 b20 mb20 1e-06
RB20 mb20 b21 0.01
CD20 a20 b20 1e-09
CGA20 a20 0 1e-10
CGB20 b20 0 1e-10
LA21 a21 ma21 1e-06
RA21 ma21 a22 0.01
LB21 b21 mb21 1e-06
RB21 mb21 b22 0.01
CD21 a21 b21 1e-09
CGA21 a21 0 1e-10
CGB21 b21 0 1e-10
LA22 a22 ma22 1e-06
RA22 ma22 a23 0.01
LB22 b22 mb22 1e-06
RB22 mb22 b23 0.01
CD22 a22 b22 1e-09
CGA22 a22 0 1e-10
CGB22 b22 0 1e-10
LA23 a23 ma23 1e-06
RA23 ma23 a24 0.01
LB23 b23 mb23 1e-06
RB23 mb23 b24 0.01
CD23 a23 b23 1e-09
CGA23 a23 0 1e-10
CGB23 b23 0 1e-10
LA24 a24 ma24 1e-06
RA24 ma24 a25 0.01
LB24 b24 mb24 1e-06
RB24 mb24 b25 0.01
CD24 a24 b24 1e-09
CGA24 a24 0 1e-10
CGB24 b24 0 1e-10
LA25 a25 ma25 1e-06
RA25 ma25 a26 0.01
LB25 b25 mb25 1e-06
RB25 mb25 b26 0.01
CD25 a25 b25 1e-09
CGA25 a25 0 1e-10
CGB25 b25 0 1e-10
LA26 a26 ma26 1e-06
RA26 ma26 a27 0.01
LB26 b26 mb26 1e-06
RB26 mb26 b27 0.01
CD26 a26 b26 1e-09
CGA26 a26 0 1e-10
CGB26 b26 0 1e-10
LA27 a27 ma27 1e-06
RA27 ma27 a28 0.01
LB27 b27 mb27 1e-06
RB27 mb27 b28 0.01
CD27 a27 b27 1e-09
CGA27 a27 0 1e-10
CGB27 b27 0 1e-10
LA28 a28 ma28 1e-06
RA28 ma28 a29 0.01
LB28 b28 mb28 1e-06
RB28 mb28 b29 0.01
CD28 a28 b28 1e-09
CGA28 a28 0 1e-10
CGB28 b28 0 1e-10
LA29 a29 ma29 1e-06
RA29 ma29 a30 0.01
LB29 b29 mb29 1e-06
RB29 mb29 b30 0.01
CD29 a29 b29 1e-09
CGA29 a29 0 1e-10
CGB29 b29 0 1e-10
LA30 a30 ma30 1e-06
RA30 ma30 a31 0.01
LB30 b30 mb30 1e-06
RB30 mb30 b31 0.01
CD30 a30 b30 1e-09
CGA30 a30 0 1e-10
CGB30 b30 0 1e-10
LA31 a31 ma31 1e-06
RA31 ma31 a32 0.01
LB31 b31 mb31 1e-06
RB31 mb31 b32 0.01
CD31 a31 b31 1e-09
CGA31 a31 0 1e-10
CGB31 b31 0 1e-10
LA32 a32 ma32 1e-06
RA32 ma32 a33 0.01
LB32 b32 mb32 1e-06
RB32 mb32 b33 0.01
CD32 a32 b32 1e-09
CGA32 a32 0 1e-10
CGB32 b32 0 1e-10
LA33 a33 ma33 1e-06
RA33 ma33 a34 0.01
LB33 b33 mb33 1e-06
RB33 mb33 b34 0.01
CD33 a33 b33 1e-09
CGA33 a33 0 1e-10
CGB33 b33 0 1e-10
LA34 a34 ma34 1e-06
RA34 ma34 a35 0.01
LB34 b34 mb34 1e-06
RB34 mb34 b35 0.01
CD34 a34 b34 1e-09
CGA34 a34 0 1e-10
CGB34 b34 0 1e-10
LA35 a35 ma35 1e-06
RA35 ma35 a36 0.01
LB35 b35 mb35 1e-06
RB35 mb35 b36 0.01
CD35 a35 b35 1e-09
CGA35 a35 0 1e-10
CGB35 b35 0 1e-10
LA36 a36 ma36 1e-06
RA36 ma36 a37 0.01
LB36 b36 mb36 1e-06
RB36 mb36 b37 0.01
CD36 a36 b36 1e-09
CGA36 a36 0 1e-10
CGB36 b36 0 1e-10
LA37 a37 ma37 1e-06
RA37 ma37 a38 0.01
LB37 b37 mb37 1e-06
RB37 mb37 b38 0.01
CD37 a37 b37 1e-09
CGA37 a37 0 1e-10
CGB37 b37 0 1e-10
LA38 a38 ma38 1e-06
RA38 ma38 a39 0.01
LB38 b38 mb38 1e-06
RB38 mb38 b39 0.01
CD38 a38 b38 1e-09
CGA38 a38 0 1e-10
CGB38 b38 0 1e-10
LA39 a39 ma39 1e-06
RA39 ma39 a40 0.01
LB39 b39 mb39 1e-06
RB39 mb39 b40 0.01
CD39 a39 b39 1e-09
CGA39 a39 0 1e-10
CGB39 b39 0 1e-10
LA40 a40 ma40 1e-06
RA40 ma40 a41 0.01
LB40 b40 mb40 1e-06
RB40 mb40 b41 0.01
CD40 a40 b40 1e-09
CGA40 a40 0 1e-10
CGB40 b40 0 1e-10
LA41 a41 ma41 1e-06
RA41 ma41 a42 0.01
LB41 b41 mb41 1e-06
RB41 mb41 b42 0.01
CD41 a41 b41 1e-09
CGA41 a41 0 1e-10
CGB41 b41 0 1e-10
LA42 a42 ma42 1e-06
RA42 ma42 a43 0.01
LB42 b42 mb42 1e-06
RB42 mb42 b43 0.01
CD42 a42 b42 1e-09
CGA42 a42 0 1e-10
CGB42 b42 0 1e-10
LA43 a43 ma43 1e-06
RA43 ma43 a44 0.01
LB43 b43 mb43 1e-06
RB43 mb43 b44 0.01
CD43 a43 b43 1e-09
CGA43 a43 0 1e-10
CGB43 b43 0 1e-10
LA44 a44 ma44 1e-06
RA44 ma44 a45 0.01
LB44 b44 mb44 1e-06
RB44 mb44 b45 0.01
CD44 a44 b44 1e-09
CGA44 a44 0 1e-10
CGB44 b44 0 1e-10
LA45 a45 ma45 1e-06
RA45 ma45 a46 0.01
LB45 b45 mb45 1e-06
RB45 mb45 b46 0.01
CD45 a45 b45 1e-09
CGA45 a45 0 1e-10
CGB45 b45 0 1e-10
LA46 a46 ma46 1e-06
RA46 ma46 a47 0.01
LB46 b46 mb46 1e-06
RB46 mb46 b47 0.01
CD46 a46 b46 1e-09
CGA46 a46 0 1e-10
CGB46 b46 0 1e-10
LA47 a47 ma47 1e-06
RA47 ma47 a48 0.01
LB47 b47 mb47 1e-06
RB47 mb47 b48 0.01
CD47 a47 b47 1e-09
CGA47 a47 0 1e-10
CGB47 b47 0 1e-10
LA48 a48 ma48 1e-06
RA48 ma48 a49 0.01
LB48 b48 mb48 1e-06
RB48 mb48 b49 0.01
CD48 a48 b48 1e-09
CGA48 a48 0 1e-10
CGB48 b48 0 1e-10
LA49 a49 ma49 1e-06
RA49 ma49 a50 0.01
LB49 b49 mb49 1e-06
RB49 mb49 b50 0.01
CD49 a49 b49 1e-09
CGA49 a49 0 1e-10
CGB49 b49 0 1e-10
LA50 a50 ma50 1e-06
RA50 ma50 a51 0.01
LB50 b50 mb50 1e-06
RB50 mb50 b51 0.01
CD50 a50 b50 1e-09
CGA50 a50 0 1e-10
CGB50 b50 0 1e-10
LA51 a51 ma51 1e-06
RA51 ma51 a52 0.01
LB51 b51 mb51 1e-06
RB51 mb51 b52 0.01
CD51 a51 b51 1e-09
CGA51 a51 0 1e-10
CGB51 b51 0 1e-10
LA52 a52 ma52 1e-06
RA52 ma52 a53 0.01
LB52 b52 mb52 1e-06
RB52 mb52 b53 0.01
CD52 a52 b52 1e-09
CGA52 a52 0 1e-10
CGB52 b52 0 1e-10
LA53 a53 ma53 1e-06
RA53 ma53 a54 0.01
LB53 b53 mb53 1e-06
RB53 mb53 b54 0.01
CD53 a53 b53 1e-09
CGA53 a53 0 1e-10
CGB53 b53 0 1e-10
LA54 a54 ma54 1e-06
RA54 ma54 a55 0.01
LB54 b54 mb54 1e-06
RB54 mb54 b55 0.01
CD54 a54 b54 1e-09
CGA54 a54 0 1e-10
CGB54 b54 0 1e-10
LA55 a55 ma55 1e-06
RA55 ma55 a56 0.01
LB55 b55 mb55 1e-06
RB55 mb55 b56 0.01
CD55 a55 b55 1e-09
CGA55 a55 0 1e-10
CGB55 b55 0 1e-10
LA56 a56 ma56 1e-06
RA56 ma56 a57 0.01
LB56 b56 mb56 1e-06
RB56 mb56 b57 0.01
CD56 a56 b56 1e-09
CGA56 a56 0 1e-10
CGB56 b56 0 1e-10
LA57 a57 ma57 1e-06
RA57 ma57 a58 0.01
LB57 b57 mb57 1e-06
RB57 mb57 b58 0.01
CD57 a57 b57 1e-09
CGA57 a57 0 1e-10
CGB57 b57 0 1e-10
LA58 a58 ma58 1e-06
RA58 ma58 a59 0.01
LB58 b58 mb58 1e-06
RB58 mb58 b59 0.01
CD58 a58 b58 1e-09
CGA58 a58 0 1e-10
CGB58 b58 0 1e-10
LA59 a59 ma59 1e-06
RA59 ma59 a60 0.01
LB59 b59 mb59 1e-06
RB59 mb59 b60 0.01
CD59 a59 b59 1e-09
CGA59 a59 0 1e-10
CGB59 b59 0 1e-10
LA60 a60 ma60 1e-06
RA60 ma60 a61 0.01
LB60 b60 mb60 1e-06
RB60 mb60 b61 0.01
CD60 a60 b60 1e-09
CGA60 a60 0 1e-10
CGB60 b60 0 1e-10
LA61 a61 ma61 1e-06
RA61 ma61 a62 0.01
LB61 b61 mb61 1e-06
RB61 mb61 b62 0.01
CD61 a61 b61 1e-09
CGA61 a61 0 1e-10
CGB61 b61 0 1e-10
LA62 a62 ma62 1e-06
RA62 ma62 a63 0.01
LB62 b62 mb62 1e-06
RB62 mb62 b63 0.01
CD62 a62 b62 1e-09
CGA62 a62 0 1e-10
CGB62 b62 0 1e-10
LA63 a63 ma63 1e-06
RA63 ma63 a64 0.01
LB63 b63 mb63 1e-06
RB63 mb63 b64 0.01
CD63 a63 b63 1e-09
CGA63 a63 0 1e-10
CGB63 b63 0 1e-10
LA64 a64 ma64 1e-06
RA64 ma64 a65 0.01
LB64 b64 mb64 1e-06
RB64 mb64 b65 0.01
CD64 a64 b64 1e-09
CGA64 a64 0 1e-10
CGB64 b64 0 1e-10
LA65 a65 ma65 1e-06
RA65 ma65 a66 0.01
LB65 b65 mb65 1e-06
RB65 mb65 b66 0.01
CD65 a65 b65 1e-09
CGA65 a65 0 1e-10
CGB65 b65 0 1e-10
LA66 a66 ma66 1e-06
RA66 ma66 a67 0.01
LB66 b66 mb66 1e-06
RB66 mb66 b67 0.01
CD66 a66 b66 1e-09
CGA66 a66 0 1e-10
CGB66 b66 0 1e-10
LA67 a67 ma67 1e-06
RA67 ma67 a68 0.01
LB67 b67 mb67 1e-06
RB67 mb67 b68 0.01
CD67 a67 b67 1e-09
CGA67 a67 0 1e-10
CGB67 b67 0 1e-10
LA68 a68 ma68 1e-06
RA68 ma68 a69 0.01
LB68 b68 mb68 1e-06
RB68 mb68 b69 0.01
CD68 a68 b68 1e-09
CGA68 a68 0 1e-10
CGB68 b68 0 1e-10
LA69 a69 ma69 1e-06
RA69 ma69 a70 0.01
LB69 b69 mb69 1e-06
RB69 mb69 b70 0.01
CD69 a69 b69 1e-09
CGA69 a69 0 1e-10
CGB69 b69 0 1e-10
LA70 a70 ma70 1e-06
RA70 ma70 a71 0.01
LB70 b70 mb70 1e-06
RB70 mb70 b71 0.01
CD70 a70 b70 1e-09
CGA70 a70 0 1e-10
CGB70 b70 0 1e-10
LA71 a71 ma71 1e-06
RA71 ma71 a72 0.01
LB71 b71 mb71 1e-06
RB71 mb71 b72 0.01
CD71 a71 b71 1e-09
CGA71 a71 0 1e-10
CGB71 b71 0 1e-10
LA72 a72 ma72 1e-06
RA72 ma72 a73 0.01
LB72 b72 mb72 1e-06
RB72 mb72 b73 0.01
CD72 a72 b72 1e-09
CGA72 a72 0 1e-10
CGB72 b72 0 1e-10
LA73 a73 ma73 1e-06
RA73 ma73 a74 0.01
LB73 b73 mb73 1e-06
RB73 mb73 b74 0.01
CD73 a73 b73 1e-09
CGA73 a73 0 1e-10
CGB73 b73 0 1e-10
LA74 a74 ma74 1e-06
RA74 ma74 a75 0.01
LB74 b74 mb74 1e-06
RB74 mb74 b75 0.01
CD74 a74 b74 1e-09
CGA74 a74 0 1e-10
CGB74 b74 0 1e-10
LA75 a75 ma75 1e-06
RA75 ma75 a76 0.01
LB75 b75 mb75 1e-06
RB75 mb75 b76 0.01
CD75 a75 b75 1e-09
CGA75 a75 0 1e-10
CGB75 b75 0 1e-10
LA76 a76 ma76 1e-06
RA76 ma76 a77 0.01
LB76 b76 mb76 1e-06
RB76 mb76 b77 0.01
CD76 a76 b76 1e-09
CGA76 a76 0 1e-10
CGB76 b76 0 1e-10
LA77 a77 ma77 1e-06
RA77 ma77 a78 0.01
LB77 b77 mb77 1e-06
RB77 mb77 b78 0.01
CD77 a77 b77 1e-09
CGA77 a77 0 1e-10
CGB77 b77 0 1e-10
LA78 a78 ma78 1e-06
RA78 ma78 a79 0.01
LB78 b78 mb78 1e-06
RB78 mb78 b79 0.01
CD78 a78 b78 1e-09
CGA78 a78 0 1e-10
CGB78 b78 0 1e-10
LA79 a79 ma79 1e-06
RA79 ma79 a80 0.01
LB79 b79 mb79 1e-06
RB79 mb79 b80 0.01
CD79 a79 b79 1e-09
CGA79 a79 0 1e-10
CGB79 b79 0 1e-10
LA80 a80 ma80 1e-06
RA80 ma80 a81 0.01
LB80 b80 mb80 1e-06
RB80 mb80 b81 0.01
CD80 a80 b80 1e-09
CGA80 a80 0 1e-10
CGB80 b80 0 1e-10
LA81 a81 ma81 1e-06
RA81 ma81 a82 0.01
LB81 b81 mb81 1e-06
RB81 mb81 b82 0.01
CD81 a81 b81 1e-09
CGA81 a81 0 1e-10
CGB81 b81 0 1e-10
LA82 a82 ma82 1e-06
RA82 ma82 a83 0.01
LB82 b82 mb82 1e-06
RB82 mb82 b83 0.01
CD82 a82 b82 1e-09
CGA82 a82 0 1e-10
CGB82 b82 0 1e-10
LA83 a83 ma83 1e-06
RA83 ma83 a84 0.01
LB83 b83 mb83 1e-06
RB83 mb83 b84 0.01
CD83 a83 b83 1e-09
CGA83 a83 0 1e-10
CGB83 b83 0 1e-10
LA84 a84 ma84 1e-06
RA84 ma84 a85 0.01
LB84 b84 mb84 1e-06
RB84 mb84 b85 0.01
CD84 a84 b84 1e-09
CGA84 a84 0 1e-10
CGB84 b84 0 1e-10
LA85 a85 ma85 1e-06
RA85 ma85 a86 0.01
LB85 b85 mb85 1e-06
RB85 mb85 b86 0.01
CD85 a85 b85 1e-09
CGA85 a85 0 1e-10
CGB85 b85 0 1e-10
LA86 a86 ma86 1e-06
RA86 ma86 a87 0.01
LB86 b86 mb86 1e-06
RB86 mb86 b87 0.01
CD86 a86 b86 1e-09
CGA86 a86 0 1e-10
CGB86 b86 0 1e-10
LA87 a87 ma87 1e-06
RA87 ma87 a88 0.01
LB87 b87 mb87 1e-06
RB87 mb87 b88 0.01
CD87 a87 b87 1e-09
CGA87 a87 0 1e-10
CGB87 b87 0 1e-10
LA88 a88 ma88 1e-06
RA88 ma88 a89 0.01
LB88 b88 mb88 1e-06
RB88 mb88 b89 0.01
CD88 a88 b88 1e-09
CGA88 a88 0 1e-10
CGB88 b88 0 1e-10
LA89 a89 ma89 1e-06
RA89 ma89 a90 0.01
LB89 b89 mb89 1e-06
RB89 mb89 b90 0.01
CD89 a89 b89 1e-09
CGA89 a89 0 1e-10
CGB89 b89 0 1e-10
LA90 a90 ma90 1e-06
RA90 ma90 a91 0.01
LB90 b90 mb90 1e-06
RB90 mb90 b91 0.01
CD90 a90 b90 1e-09
CGA90 a90 0 1e-10
CGB90 b90 0 1e-10
LA91 a91 ma91 1e-06
RA91 ma91 a92 0.01
LB91 b91 mb91 1e-06
RB91 mb91 b92 0.01
CD91 a91 b91 1e-09
CGA91 a91 0 1e-10
CGB91 b91 0 1e-10
LA92 a92 ma92 1e-06
RA92 ma92 a93 0.01
LB92 b92 mb92 1e-06
RB92 mb92 b93 0.01
CD92 a92 b92 1e-09
CGA92 a92 0 1e-10
CGB92 b92 0 1e-10
LA93 a93 ma93 1e-06
RA93 ma93 a94 0.01
LB93 b93 mb93 1e-06
RB93 mb93 b94 0.01
CD93 a93 b93 1e-09
CGA93 a93 0 1e-10
CGB93 b93 0 1e-10
LA94 a94 ma94 1e-06
RA94 ma94 a95 0.01
LB94 b94 mb94 1e-06
RB94 mb94 b95 0.01
CD94 a94 b94 1e-09
CGA94 a94 0 1e-10
CGB94 b94 0 1e-10
LA95 a95 ma95 1e-06
RA95 ma95 a96 0.01
LB95 b95 mb95 1e-06
RB95 mb95 b96 0.01
CD95 a95 b95 1e-09
CGA95 a95 0 1e-10
CGB95 b95 0 1e-10
LA96 a96 ma96 1e-06
RA96 ma96 a97 0.01
LB96 b96 mb96 1e-06
RB96 mb96 b97 0.01
CD96 a96 b96 1e-09
CGA96 a96 0 1e-10
CGB96 b96 0 1e-10
LA97 a97 ma97 1e-06
RA97 ma97 a98 0.01
LB97 b97 mb97 1e-06
RB97 mb97 b98 0.01
CD97 a97 b97 1e-09
CGA97 a97 0 1e-10
CGB97 b97 0 1e-10
LA98 a98 ma98 1e-06
RA98 ma98 a99 0.01
LB98 b98 mb98 1e-06
RB98 mb98 b99 0.01
CD98 a98 b98 1e-09
CGA98 a98 0 1e-10
CGB98 b98 0 1e-10
LA99 a99 ma99 1e-06
RA99 ma99 a100 0.01
LB99 b99 mb99 1e-06
RB99 mb99 b100 0.01
CD99 a99 b99 1e-09
CGA99 a99 0 1e-10
CGB99 b99 0 1e-10
LA100 a100 ma100 1e-06
RA100 ma100 a101 0.01
LB100 b100 mb100 1e-06
RB100 mb100 b101 0.01
CD100 a100 b100 1e-09
CGA100 a100 0 1e-10
CGB100 b100 0 1e-10
LA101 a101 ma101 1e-06
RA101 ma101 a102 0.01
LB101 b101 mb101 1e-06
RB101 mb101 b102 0.01
CD101 a101 b101 1e-09
CGA101 a101 0 1e-10
CGB101 b101 0 1e-10
LA102 a102 ma102 1e-06
RA102 ma102 a103 0.01
LB102 b102 mb102 1e-06
RB102 mb102 b103 0.01
CD102 a102 b102 1e-09
CGA102 a102 0 1e-10
CGB102 b102 0 1e-10
LA103 a103 ma103 1e-06
RA103 ma103 a104 0.01
LB103 b103 mb103 1e-06
RB103 mb103 b104 0.01
CD103 a103 b103 1e-09
CGA103 a103 0 1e-10
CGB103 b103 0 1e-10
LA104 a104 ma104 1e-06
RA104 ma104 a105 0.01
LB104 b104 mb104 1e-06
RB104 mb104 b105 0.01
CD104 a104 b104 1e-09
CGA104 a104 0 1e-10
CGB104 b104 0 1e-10
LA105 a105 ma105 1e-06
RA105 ma105 a106 0.01
LB105 b105 mb105 1e-06
RB105 mb105 b106 0.01
CD105 a105 b105 1e-09
CGA105 a105 0 1e-10
CGB105 b105 0 1e-10
LA106 a106 ma106 1e-06
RA106 ma106 a107 0.01
LB106 b106 mb106 1e-06
RB106 mb106 b107 0.01
CD106 a106 b106 1e-09
CGA106 a106 0 1e-10
CGB106 b106 0 1e-10
LA107 a107 ma107 1e-06
RA107 ma107 a108 0.01
LB107 b107 mb107 1e-06
RB107 mb107 b108 0.01
CD107 a107 b107 1e-09
CGA107 a107 0 1e-10
CGB107 b107 0 1e-10
LA108 a108 ma108 1e-06
RA108 ma108 a109 0.01
LB108 b108 mb108 1e-06
RB108 mb108 b109 0.01
CD108 a108 b108 1e-09
CGA108 a108 0 1e-10
CGB108 b108 0 1e-10
LA109 a109 ma109 1e-06
RA109 ma109 a110 0.01
LB109 b109 mb109 1e-06
RB109 mb109 b110 0.01
CD109 a109 b109 1e-09
CGA109 a109 0 1e-10
CGB109 b109 0 1e-10
LA110 a110 ma110 1e-06
RA110 ma110 a111 0.01
LB110 b110 mb110 1e-06
RB110 mb110 b111 0.01
CD110 a110 b110 1e-09
CGA110 a110 0 1e-10
CGB110 b110 0 1e-10
LA111 a111 ma111 1e-06
RA111 ma111 a112 0.01
LB111 b111 mb111 1e-06
RB111 mb111 b112 0.01
CD111 a111 b111 1e-09
CGA111 a111 0 1e-10
CGB111 b111 0 1e-10
LA112 a112 ma112 1e-06
RA112 ma112 a113 0.01
LB112 b112 mb112 1e-06
RB112 mb112 b113 0.01
CD112 a112 b112 1e-09
CGA112 a112 0 1e-10
CGB112 b112 0 1e-10
LA113 a113 ma113 1e-06
RA113 ma113 a114 0.01
LB113 b113 mb113 1e-06
RB113 mb113 b114 0.01
CD113 a113 b113 1e-09
CGA113 a113 0 1e-10
CGB113 b113 0 1e-10
LA114 a114 ma114 1e-06
RA114 ma114 a115 0.01
LB114 b114 mb114 1e-06
RB114 mb114 b115 0.01
CD114 a114 b114 1e-09
CGA114 a114 0 1e-10
CGB114 b114 0 1e-10
LA115 a115 ma115 1e-06
RA115 ma115 a116 0.01
LB115 b115 mb115 1e-06
RB115 mb115 b116 0.01
CD115 a115 b115 1e-09
CGA115 a115 0 1e-10
CGB115 b115 0 1e-10
LA116 a116 ma116 1e-06
RA116 ma116 a117 0.01
LB116 b116 mb116 1e-06
RB116 mb116 b117 0.01
CD116 a116 b116 1e-09
CGA116 a116 0 1e-10
CGB116 b116 0 1e-10
LA117 a117 ma117 1e-06
RA117 ma117 a118 0.01
LB117 b117 mb117 1e-06
RB117 mb117 b118 0.01
CD117 a117 b117 1e-09
CGA117 a117 0 1e-10
CGB117 b117 0 1e-10
LA118 a118 ma118 1e-06
RA118 ma118 a119 0.01
LB118 b118 mb118 1e-06
RB118 mb118 b119 0.01
CD118 a118 b118 1e-09
CGA118 a118 0 1e-10
CGB118 b118 0 1e-10
LA119 a119 ma119 1e-06
RA119 ma119 a120 0.01
LB119 b119 mb119 1e-06
RB119 mb119 b120 0.01
CD119 a119 b119 1e-09
CGA119 a119 0 1e-10
CGB119 b119 0 1e-10
LA120 a120 ma120 1e-06
RA120 ma120 a121 0.01
LB120 b120 mb120 1e-06
RB120 mb120 b121 0.01
CD120 a120 b120 1e-09
CGA120 a120 0 1e-10
CGB120 b120 0 1e-10
LA121 a121 ma121 1e-06
RA121 ma121 a122 0.01
LB121 b121 mb121 1e-06
RB121 mb121 b122 0.01
CD121 a121 b121 1e-09
CGA121 a121 0 1e-10
CGB121 b121 0 1e-10
LA122 a122 ma122 1e-06
RA122 ma122 a123 0.01
LB122 b122 mb122 1e-06
RB122 mb122 b123 0.01
CD122 a122 b122 1e-09
CGA122 a122 0 1e-10
CGB122 b122 0 1e-10
LA123 a123 ma123 1e-06
RA123 ma123 a124 0.01
LB123 b123 mb123 1e-06
RB123 mb123 b124 0.01
CD123 a123 b123 1e-09
CGA123 a123 0 1e-10
CGB123 b123 0 1e-10
LA124 a124 ma124 1e-06
RA124 ma124 a125 0.01
LB124 b124 mb124 1e-06
RB124 mb124 b125 0.01
CD124 a124 b124 1e-09
CGA124 a124 0 1e-10
CGB124 b124 0 1e-10
LA125 a125 ma125 1e-06
RA125 ma125 a126 0.01
LB125 b125 mb125 1e-06
RB125 mb125 b126 0.01
CD125 a125 b125 1e-09
CGA125 a125 0 1e-10
CGB125 b125 0 1e-10
LA126 a126 ma126 1e-06
RA126 ma126 a127 0.01
LB126 b126 mb126 1e-06
RB126 mb126 b127 0.01
CD126 a126 b126 1e-09
CGA126 a126 0 1e-10
CGB126 b126 0 1e-10
LA127 a127 ma127 1e-06
RA127 ma127 a128 0.01
LB127 b127 mb127 1e-06
RB127 mb127 b128 0.01
CD127 a127 b127 1e-09
CGA127 a127 0 1e-10
CGB127 b127 0 1e-10
LA128 a128 ma128 1e-06
RA128 ma128 a129 0.01
LB128 b128 mb128 1e-06
RB128 mb128 b129 0.01
CD128 a128 b128 1e-09
CGA128 a128 0 1e-10
CGB128 b128 0 1e-10
LA129 a129 ma129 1e-06
RA129 ma129 a130 0.01
LB129 b129 mb129 1e-06
RB129 mb129 b130 0.01
CD129 a129 b129 1e-09
CGA129 a129 0 1e-10
CGB129 b129 0 1e-10
LA130 a130 ma130 1e-06
RA130 ma130 a131 0.01
LB130 b130 mb130 1e-06
RB130 mb130 b131 0.01
CD130 a130 b130 1e-09
CGA130 a130 0 1e-10
CGB130 b130 0 1e-10
LA131 a131 ma131 1e-06
RA131 ma131 a132 0.01
LB131 b131 mb131 1e-06
RB131 mb131 b132 0.01
CD131 a131 b131 1e-09
CGA131 a131 0 1e-10
CGB131 b131 0 1e-10
LA132 a132 ma132 1e-06
RA132 ma132 a133 0.01
LB132 b132 mb132 1e-06
RB132 mb132 b133 0.01
CD132 a132 b132 1e-09
CGA132 a132 0 1e-10
CGB132 b132 0 1e-10
LA133 a133 ma133 1e-06
RA133 ma133 a134 0.01
LB133 b133 mb133 1e-06
RB133 mb133 b134 0.01
CD133 a133 b133 1e-09
CGA133 a133 0 1e-10
CGB133 b133 0 1e-10
LA134 a134 ma134 1e-06
RA134 ma134 a135 0.01
LB134 b134 mb134 1e-06
RB134 mb134 b135 0.01
CD134 a134 b134 1e-09
CGA134 a134 0 1e-10
CGB134 b134 0 1e-10
LA135 a135 ma135 1e-06
RA135 ma135 a136 0.01
LB135 b135 mb135 1e-06
RB135 mb135 b136 0.01
CD135 a135 b135 1e-09
CGA135 a135 0 1e-10
CGB135 b135 0 1e-10
LA136 a136 ma136 1e-06
RA136 ma136 a137 0.01
LB136 b136 mb136 1e-06
RB136 mb136 b137 0.01
CD136 a136 b136 1e-09
CGA136 a136 0 1e-10
CGB136 b136 0 1e-10
LA137 a137 ma137 1e-06
RA137 ma137 a138 0.01
LB137 b137 mb137 1e-06
RB137 mb137 b138 0.01
CD137 a137 b137 1e-09
CGA137 a137 0 1e-10
CGB137 b137 0 1e-10
LA138 a138 ma138 1e-06
RA138 ma138 a139 0.01
LB138 b138 mb138 1e-06
RB138 mb138 b139 0.01
CD138 a138 b138 1e-09
CGA138 a138 0 1e-10
CGB138 b138 0 1e-10
LA139 a139 ma139 1e-06
RA139 ma139 a140 0.01
LB139 b139 mb139 1e-06
RB139 mb139 b140 0.01
CD139 a139 b139 1e-09
CGA139 a139 0 1e-10
CGB139 b139 0 1e-10
LA140 a140 ma140 1e-06
RA140 ma140 a141 0.01
LB140 b140 mb140 1e-06
RB140 mb140 b141 0.01
CD140 a140 b140 1e-09
CGA140 a140 0 1e-10
CGB140 b140 0 1e-10
LA141 a141 ma141 1e-06
RA141 ma141 a142 0.01
LB141 b141 mb141 1e-06
RB141 mb141 b142 0.01
CD141 a141 b141 1e-09
CGA141 a141 0 1e-10
CGB141 b141 0 1e-10
LA142 a142 ma142 1e-06
RA142 ma142 a143 0.01
LB142 b142 mb142 1e-06
RB142 mb142 b143 0.01
CD142 a142 b142 1e-09
CGA142 a142 0 1e-10
CGB142 b142 0 1e-10
LA143 a143 ma143 1e-06
RA143 ma143 a144 0.01
LB143 b143 mb143 1e-06
RB143 mb143 b144 0.01
CD143 a143 b143 1e-09
CGA143 a143 0 1e-10
CGB143 b143 0 1e-10
LA144 a144 ma144 1e-06
RA144 ma144 a145 0.01
LB144 b144 mb144 1e-06
RB144 mb144 b145 0.01
CD144 a144 b144 1e-09
CGA144 a144 0 1e-10
CGB144 b144 0 1e-10
LA145 a145 ma145 1e-06
RA145 ma145 a146 0.01
LB145 b145 mb145 1e-06
RB145 mb145 b146 0.01
CD145 a145 b145 1e-09
CGA145 a145 0 1e-10
CGB145 b145 0 1e-10
LA146 a146 ma146 1e-06
RA146 ma146 a147 0.01
LB146 b146 mb146 1e-06
RB146 mb146 b147 0.01
CD146 a146 b146 1e-09
CGA146 a146 0 1e-10
CGB146 b146 0 1e-10
LA147 a147 ma147 1e-06
RA147 ma147 a148 0.01
LB147 b147 mb147 1e-06
RB147 mb147 b148 0.01
CD147 a147 b147 1e-09
CGA147 a147 0 1e-10
CGB147 b147 0 1e-10
LA148 a148 ma148 1e-06
RA148 ma148 a149 0.01
LB148 b148 mb148 1e-06
RB148 mb148 b149 0.01
CD148 a148 b148 1e-09
CGA148 a148 0 1e-10
CGB148 b148 0 1e-10
LA149 a149 ma149 1e-06
RA149 ma149 a150 0.01
LB149 b149 mb149 1e-06
RB149 mb149 b150 0.01
CD149 a149 b149 1e-09
CGA149 a149 0 1e-10
CGB149 b149 0 1e-10
LA150 a150 ma150 1e-06
RA150 ma150 a151 0.01
LB150 b150 mb150 1e-06
RB150 mb150 b151 0.01
CD150 a150 b150 1e-09
CGA150 a150 0 1e-10
CGB150 b150 0 1e-10
LA151 a151 ma151 1e-06
RA151 ma151 a152 0.01
LB151 b151 mb151 1e-06
RB151 mb151 b152 0.01
CD151 a151 b151 1e-09
CGA151 a151 0 1e-10
CGB151 b151 0 1e-10
LA152 a152 ma152 1e-06
RA152 ma152 a153 0.01
LB152 b152 mb152 1e-06
RB152 mb152 b153 0.01
CD152 a152 b152 1e-09
CGA152 a152 0 1e-10
CGB152 b152 0 1e-10
LA153 a153 ma153 1e-06
RA153 ma153 a154 0.01
LB153 b153 mb153 1e-06
RB153 mb153 b154 0.01
CD153 a153 b153 1e-09
CGA153 a153 0 1e-10
CGB153 b153 0 1e-10
LA154 a154 ma154 1e-06
RA154 ma154 a155 0.01
LB154 b154 mb154 1e-06
RB154 mb154 b155 0.01
CD154 a154 b154 1e-09
CGA154 a154 0 1e-10
CGB154 b154 0 1e-10
LA155 a155 ma155 1e-06
RA155 ma155 a156 0.01
LB155 b155 mb155 1e-06
RB155 mb155 b156 0.01
CD155 a155 b155 1e-09
CGA155 a155 0 1e-10
CGB155 b155 0 1e-10
LA156 a156 ma156 1e-06
RA156 ma156 a157 0.01
LB156 b156 mb156 1e-06
RB156 mb156 b157 0.01
CD156 a156 b156 1e-09
CGA156 a156 0 1e-10
CGB156 b156 0 1e-10
LA157 a157 ma157 1e-06
RA157 ma157 a158 0.01
LB157 b157 mb157 1e-06
RB157 mb157 b158 0.01
CD157 a157 b157 1e-09
CGA157 a157 0 1e-10
CGB157 b157 0 1e-10
LA158 a158 ma158 1e-06
RA158 ma158 a159 0.01
LB158 b158 mb158 1e-06
RB158 mb158 b159 0.01
CD158 a158 b158 1e-09
CGA158 a158 0 1e-10
CGB158 b158 0 1e-10
LA159 a159 ma159 1e-06
RA159 ma159 a160 0.01
LB159 b159 mb159 1e-06
RB159 mb159 b160 0.01
CD159 a159 b159 1e-09
CGA159 a159 0 1e-10
CGB159 b159 0 1e-10
LA160 a160 ma160 1e-06
RA160 ma160 a161 0.01
LB160 b160 mb160 1e-06
RB160 mb160 b161 0.01
CD160 a160 b160 1e-09
CGA160 a160 0 1e-10
CGB160 b160 0 1e-10
LA161 a161 ma161 1e-06
RA161 ma161 a162 0.01
LB161 b161 mb161 1e-06
RB161 mb161 b162 0.01
CD161 a161 b161 1e-09
CGA161 a161 0 1e-10
CGB161 b161 0 1e-10
LA162 a162 ma162 1e-06
RA162 ma162 a163 0.01
LB162 b162 mb162 1e-06
RB162 mb162 b163 0.01
CD162 a162 b162 1e-09
CGA162 a162 0 1e-10
CGB162 b162 0 1e-10
LA163 a163 ma163 1e-06
RA163 ma163 a164 0.01
LB163 b163 mb163 1e-06
RB163 mb163 b164 0.01
CD163 a163 b163 1e-09
CGA163 a163 0 1e-10
CGB163 b163 0 1e-10
LA164 a164 ma164 1e-06
RA164 ma164 a165 0.01
LB164 b164 mb164 1e-06
RB164 mb164 b165 0.01
CD164 a164 b164 1e-09
CGA164 a164 0 1e-10
CGB164 b164 0 1e-10
LA165 a165 ma165 1e-06
RA165 ma165 a166 0.01
LB165 b165 mb165 1e-06
RB165 mb165 b166 0.01
CD165 a165 b165 1e-09
CGA165 a165 0 1e-10
CGB165 b165 0 1e-10
LA166 a166 ma166 1e-06
RA166 ma166 a167 0.01
LB166 b166 mb166 1e-06
RB166 mb166 b167 0.01
CD166 a166 b166 1e-09
CGA166 a166 0 1e-10
CGB166 b166 0 1e-10
LA167 a167 ma167 1e-06
RA167 ma167 a168 0.01
LB167 b167 mb167 1e-06
RB167 mb167 b168 0.01
CD167 a167 b167 1e-09
CGA167 a167 0 1e-10
CGB167 b167 0 1e-10
LA168 a168 ma168 1e-06
RA168 ma168 a169 0.01
LB168 b168 mb168 1e-06
RB168 mb168 b169 0.01
CD168 a168 b168 1e-09
CGA168 a168 0 1e-10
CGB168 b168 0 1e-10
LA169 a169 ma169 1e-06
RA169 ma169 a170 0.01
LB169 b169 mb169 1e-06
RB169 mb169 b170 0.01
CD169 a169 b169 1e-09
CGA169 a169 0 1e-10
CGB169 b169 0 1e-10
LA170 a170 ma170 1e-06
RA170 ma170 a171 0.01
LB170 b170 mb170 1e-06
RB170 mb170 b171 0.01
CD170 a170 b170 1e-09
CGA170 a170 0 1e-10
CGB170 b170 0 1e-10
LA171 a171 ma171 1e-06
RA171 ma171 a172 0.01
LB171 b171 mb171 1e-06
RB171 mb171 b172 0.01
CD171 a171 b171 1e-09
CGA171 a171 0 1e-10
CGB171 b171 0 1e-10
LA172 a172 ma172 1e-06
RA172 ma172 a173 0.01
LB172 b172 mb172 1e-06
RB172 mb172 b173 0.01
CD172 a172 b172 1e-09
CGA172 a172 0 1e-10
CGB172 b172 0 1e-10
LA173 a173 ma173 1e-06
RA173 ma173 a174 0.01
LB173 b173 mb173 1e-06
RB173 mb173 b174 0.01
CD173 a173 b173 1e-09
CGA173 a173 0 1e-10
CGB173 b173 0 1e-10
LA174 a174 ma174 1e-06
RA174 ma174 a175 0.01
LB174 b174 mb174 1e-06
RB174 mb174 b175 0.01
CD174 a174 b174 1e-09
CGA174 a174 0 1e-10
CGB174 b174 0 1e-10
LA175 a175 ma175 1e-06
RA175 ma175 a176 0.01
LB175 b175 mb175 1e-06
RB175 mb175 b176 0.01
CD175 a175 b175 1e-09
CGA175 a175 0 1e-10
CGB175 b175 0 1e-10
LA176 a176 ma176 1e-06
RA176 ma176 a177 0.01
LB176 b176 mb176 1e-06
RB176 mb176 b177 0.01
CD176 a176 b176 1e-09
CGA176 a176 0 1e-10
CGB176 b176 0 1e-10
LA177 a177 ma177 1e-06
RA177 ma177 a178 0.01
LB177 b177 mb177 1e-06
RB177 mb177 b178 0.01
CD177 a177 b177 1e-09
CGA177 a177 0 1e-10
CGB177 b177 0 1e-10
LA178 a178 ma178 1e-06
RA178 ma178 a179 0.01
LB178 b178 mb178 1e-06
RB178 mb178 b179 0.01
CD178 a178 b178 1e-09
CGA178 a178 0 1e-10
CGB178 b178 0 1e-10
LA179 a179 ma179 1e-06
RA179 ma179 a180 0.01
LB179 b179 mb179 1e-06
RB179 mb179 b180 0.01
CD179 a179 b179 1e-09
CGA179 a179 0 1e-10
CGB179 b179 0 1e-10
LA180 a180 ma180 1e-06
RA180 ma180 a181 0.01
LB180 b180 mb180 1e-06
RB180 mb180 b181 0.01
CD180 a180 b180 1e-09
CGA180 a180 0 1e-10
CGB180 b180 0 1e-10
LA181 a181 ma181 1e-06
RA181 ma181 a182 0.01
LB181 b181 mb181 1e-06
RB181 mb181 b182 0.01
CD181 a181 b181 1e-09
CGA181 a181 0 1e-10
CGB181 b181 0 1e-10
LA182 a182 ma182 1e-06
RA182 ma182 a183 0.01
LB182 b182 mb182 1e-06
RB182 mb182 b183 0.01
CD182 a182 b182 1e-09
CGA182 a182 0 1e-10
CGB182 b182 0 1e-10
LA183 a183 ma183 1e-06
RA183 ma183 a184 0.01
LB183 b183 mb183 1e-06
RB183 mb183 b184 0.01
CD183 a183 b183 1e-09
CGA183 a183 0 1e-10
CGB183 b183 0 1e-10
LA184 a184 ma184 1e-06
RA184 ma184 a185 0.01
LB184 b184 mb184 1e-06
RB184 mb184 b185 0.01
CD184 a184 b184 1e-09
CGA184 a184 0 1e-10
CGB184 b184 0 1e-10
LA185 a185 ma185 1e-06
RA185 ma185 a186 0.01
LB185 b185 mb185 1e-06
RB185 mb185 b186 0.01
CD185 a185 b185 1e-09
CGA185 a185 0 1e-10
CGB185 b185 0 1e-10
LA186 a186 ma186 1e-06
RA186 ma186 a187 0.01
LB186 b186 mb186 1e-06
RB186 mb186 b187 0.01
CD186 a186 b186 1e-09
CGA186 a186 0 1e-10
CGB186 b186 0 1e-10
LA187 a187 ma187 1e-06
RA187 ma187 a188 0.01
LB187 b187 mb187 1e-06
RB187 mb187 b188 0.01
CD187 a187 b187 1e-09
CGA187 a187 0 1e-10
CGB187 b187 0 1e-10
LA188 a188 ma188 1e-06
RA188 ma188 a189 0.01
LB188 b188 mb188 1e-06
RB188 mb188 b189 0.01
CD188 a188 b188 1e-09
CGA188 a188 0 1e-10
CGB188 b188 0 1e-10
LA189 a189 ma189 1e-06
RA189 ma189 a190 0.01
LB189 b189 mb189 1e-06
RB189 mb189 b190 0.01
CD189 a189 b189 1e-09
CGA189 a189 0 1e-10
CGB189 b189 0 1e-10
LA190 a190 ma190 1e-06
RA190 ma190 a191 0.01
LB190 b190 mb190 1e-06
RB190 mb190 b191 0.01
CD190 a190 b190 1e-09
CGA190 a190 0 1e-10
CGB190 b190 0 1e-10
LA191 a191 ma191 1e-06
RA191 ma191 a192 0.01
LB191 b191 mb191 1e-06
RB191 mb191 b192 0.01
CD191 a191 b191 1e-09
CGA191 a191 0 1e-10
CGB191 b191 0 1e-10
LA192 a192 ma192 1e-06
RA192 ma192 a193 0.01
LB192 b192 mb192 1e-06
RB192 mb192 b193 0.01
CD192 a192 b192 1e-09
CGA192 a192 0 1e-10
CGB192 b192 0 1e-10
LA193 a193 ma193 1e-06
RA193 ma193 a194 0.01
LB193 b193 mb193 1e-06
RB193 mb193 b194 0.01
CD193 a193 b193 1e-09
CGA193 a193 0 1e-10
CGB193 b193 0 1e-10
LA194 a194 ma194 1e-06
RA194 ma194 a195 0.01
LB194 b194 mb194 1e-06
RB194 mb194 b195 0.01
CD194 a194 b194 1e-09
CGA194 a194 0 1e-10
CGB194 b194 0 1e-10
LA195 a195 ma195 1e-06
RA195 ma195 a196 0.01
LB195 b195 mb195 1e-06
RB195 mb195 b196 0.01
CD195 a195 b195 1e-09
CGA195 a195 0 1e-10
CGB195 b195 0 1e-10
LA196 a196 ma196 1e-06
RA196 ma196 a197 0.01
LB196 b196 mb196 1e-06
RB196 mb196 b197 0.01
CD196 a196 b196 1e-09
CGA196 a196 0 1e-10
CGB196 b196 0 1e-10
LA197 a197 ma197 1e-06
RA197 ma197 a198 0.01
LB197 b197 mb197 1e-06
RB197 mb197 b198 0.01
CD197 a197 b197 1e-09
CGA197 a197 0 1e-10
CGB197 b197 0 1e-10
LA198 a198 ma198 1e-06
RA198 ma198 a199 0.01
LB198 b198 mb198 1e-06
RB198 mb198 b199 0.01
CD198 a198 b198 1e-09
CGA198 a198 0 1e-10
CGB198 b198 0 1e-10
LA199 a199 ma199 1e-06
RA199 ma199 b0 0.01
LB199 b199 mb199 1e-06
RB199 mb199 a0 0.01
CD199 a199 b199 1e-09
CGA199 a199 0 1e-10
CGB199 b199 0 1e-10
RBA a0 0 1e+06
RBB b0 0 1e+06
IS b0 a0 DC 0 AC 1 0
.ac lin 2001 1k 450k
.end
