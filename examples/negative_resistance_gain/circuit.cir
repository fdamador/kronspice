Divider with gain: only a negative lower leg gives |H| = 2
V1 in 0 DC 1 AC 1
R1 in out 1k
R2 out 0 1k
.ac lin 1 1k 1k
.end
