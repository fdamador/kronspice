Bi–Al wet (galvanic) element with bifilar coil
Rcoil a c 2.5200000000000005
Lcoil c 0 0.00026541626116960095
Cself a 0 4.0655357391486483e-10
Relec a n1 0.026249999999999996
Vbial n1 n2 DC 1.97
Rct n2 0 1.25
Cdl n2 0 0.00016
Cgeo a 0 5.6666802001919996e-09
Iprobe 0 a DC 0 AC 1 0
.ac dec 40 1 10g
.end
