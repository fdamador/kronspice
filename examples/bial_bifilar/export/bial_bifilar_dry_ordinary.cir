Bi–Al dry (Seebeck) element with ordinary coil
Rcoil a c 2.5200000000000005
Lcoil c 0 0.00026541626116960095
Cself a 0 4.0655357391486484e-14
Rint a n1 0.0013165
Vbial n1 n2 DC 0.00755
Cplate n2 0 7.083350250239999e-10
Iprobe 0 a DC 0 AC 1 0
.ac dec 40 1 10g
.end
