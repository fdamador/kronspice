coiled_tether_bifilar_load
VSUN d 0 SIN(0 374.92722263394 565.6963039152071)
RWIRE d m 43.0416
LCOIL m top 1.362107606568154
CWIND top x 5.811151028598849e-08
RLOAD x 0 43.0416
.tran 8.838664784257556e-06 0.22152413585872918 0 8.838664784257556e-06
.end
