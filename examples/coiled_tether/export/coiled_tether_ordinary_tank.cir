coiled_tether_ordinary_tank
VSUN d 0 SIN(0 265.1135815758974 565.6963039152071)
RWIRE d m 43.0416
LCOIL m top 1.362107606568154
CWIND top 0 5.811151028598849e-08
.tran 8.838664784257556e-06 0.44304827171745836 0 8.838664784257556e-06
.end
