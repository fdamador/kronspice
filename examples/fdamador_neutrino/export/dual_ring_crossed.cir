crossed dual (CL) ring
CA0 a0 a1 1e-09
CB0 b0 b1 1e-09
LGA0 a0 ga0 1e-06
RGA0 ga0 0 0.1
LGB0 b0 gb0 1e-06
RGB0 gb0 0 0.1
CA1 a1 a2 1e-09
CB1 b1 b2 1e-09
LGA1 a1 ga1 1e-06
RGA1 ga1 0 0.1
LGB1 b1 gb1 1e-06
RGB1 gb1 0 0.1
CA2 a2 a3 1e-09
CB2 b2 b3 1e-09
LGA2 a2 ga2 1e-06
RGA2 ga2 0 0.1
LGB2 b2 gb2 1e-06
RGB2 gb2 0 0.1
CA3 a3 a4 1e-09
CB3 b3 b4 1e-09
LGA3 a3 ga3 1e-06
RGA3 ga3 0 0.1
LGB3 b3 gb3 1e-06
RGB3 gb3 0 0.1
CA4 a4 a5 1e-09
CB4 b4 b5 1e-09
LGA4 a4 ga4 1e-06
RGA4 ga4 0 0.1
LGB4 b4 gb4 1e-06
RGB4 gb4 0 0.1
CA5 a5 a6 1e-09
CB5 b5 b6 1e-09
LGA5 a5 ga5 1e-06
RGA5 ga5 0 0.1
LGB5 b5 gb5 1e-06
RGB5 gb5 0 0.1
CA6 a6 a7 1e-09
CB6 b6 b7 1e-09
LGA6 a6 ga6 1e-06
RGA6 ga6 0 0.1
LGB6 b6 gb6 1e-06
RGB6 gb6 0 0.1
CA7 a7 a8 1e-09
CB7 b7 b8 1e-09
LGA7 a7 ga7 1e-06
RGA7 ga7 0 0.1
LGB7 b7 gb7 1e-06
RGB7 gb7 0 0.1
CA8 a8 a9 1e-09
CB8 b8 b9 1e-09
LGA8 a8 ga8 1e-06
RGA8 ga8 0 0.1
LGB8 b8 gb8 1e-06
RGB8 gb8 0 0.1
CA9 a9 a10 1e-09
CB9 b9 b10 1e-09
LGA9 a9 ga9 1e-06
RGA9 ga9 0 0.1
LGB9 b9 gb9 1e-06
RGB9 gb9 0 0.1
CA10 a10 a11 1e-09
CB10 b10 b11 1e-09
LGA10 a10 ga10 1e-06
RGA10 ga10 0 0.1
LGB10 b10 gb10 1e-06
RGB10 gb10 0 0.1
CA11 a11 a12 1e-09
CB11 b11 b12 1e-09
LGA11 a11 ga11 1e-06
RGA11 ga11 0 0.1
LGB11 b11 gb11 1e-06
RGB11 gb11 0 0.1
CA12 a12 a13 1e-09
CB12 b12 b13 1e-09
LGA12 a12 ga12 1e-06
RGA12 ga12 0 0.1
LGB12 b12 gb12 1e-06
RGB12 gb12 0 0.1
CA13 a13 a14 1e-09
CB13 b13 b14 1e-09
LGA13 a13 ga13 1e-06
RGA13 ga13 0 0.1
LGB13 b13 gb13 1e-06
RGB13 gb13 0 0.1
CA14 a14 a15 1e-09
CB14 b14 b15 1e-09
LGA14 a14 ga14 1e-06
RGA14 ga14 0 0.1
LGB14 b14 gb14 1e-06
RGB14 gb14 0 0.1
CA15 a15 a16 1e-09
CB15 b15 b16 1e-09
LGA15 a15 ga15 1e-06
RGA15 ga15 0 0.1
LGB15 b15 gb15 1e-06
RGB15 gb15 0 0.1
CA16 a16 a17 1e-09
CB16 b16 b17 1e-09
LGA16 a16 ga16 1e-06
RGA16 ga16 0 0.1
LGB16 b16 gb16 1e-06
RGB16 gb16 0 0.1
CA17 a17 a18 1e-09
CB17 b17 b18 1e-09
LGA17 a17 ga17 1e-06
RGA17 ga17 0 0.1
LGB17 b17 gb17 1e-06
RGB17 gb17 0 0.1
CA18 a18 a19 1e-09
CB18 b18 b19 1e-09
LGA18 a18 ga18 1e-06
RGA18 ga18 0 0.1
LGB18 b18 gb18 1e-06
RGB18 gb18 0 0.1
CA19 a19 a20 1e-09
CB19 b19 b20 1e-09
LGA19 a19 ga19 1e-06
RGA19 ga19 0 0.1
LGB19 b19 gb19 1e-06
RGB19 gb19 0 0.1
CA20 a20 a21 1e-09
CB20 b20 b21 1e-09
LGA20 a20 ga20 1e-06
RGA20 ga20 0 0.1
LGB20 b20 gb20 1e-06
RGB20 gb20 0 0.1
CA21 a21 a22 1e-09
CB21 b21 b22 1e-09
LGA21 a21 ga21 1e-06
RGA21 ga21 0 0.1
LGB21 b21 gb21 1e-06
RGB21 gb21 0 0.1
CA22 a22 a23 1e-09
CB22 b22 b23 1e-09
LGA22 a22 ga22 1e-06
RGA22 ga22 0 0.1
LGB22 b22 gb22 1e-06
RGB22 gb22 0 0.1
CA23 a23 a24 1e-09
CB23 b23 b24 1e-09
LGA23 a23 ga23 1e-06
RGA23 ga23 0 0.1
LGB23 b23 gb23 1e-06
RGB23 gb23 0 0.1
CA24 a24 a25 1e-09
CB24 b24 b25 1e-09
LGA24 a24 ga24 1e-06
RGA24 ga24 0 0.1
LGB24 b24 gb24 1e-06
RGB24 gb24 0 0.1
CA25 a25 a26 1e-09
CB25 b25 b26 1e-09
LGA25 a25 ga25 1e-06
RGA25 ga25 0 0.1
LGB25 b25 gb25 1e-06
RGB25 gb25 0 0.1
CA26 a26 a27 1e-09
CB26 b26 b27 1e-09
LGA26 a26 ga26 1e-06
RGA26 ga26 0 0.1
LGB26 b26 gb26 1e-06
RGB26 gb26 0 0.1
CA27 a27 a28 1e-09
CB27 b27 b28 1e-09
LGA27 a27 ga27 1e-06
RGA27 ga27 0 0.1
LGB27 b27 gb27 1e-06
RGB27 gb27 0 0.1
CA28 a28 a29 1e-09
CB28 b28 b29 1e-09
LGA28 a28 ga28 1e-06
RGA28 ga28 0 0.1
LGB28 b28 gb28 1e-06
RGB28 gb28 0 0.1
CA29 a29 a30 1e-09
CB29 b29 b30 1e-09
LGA29 a29 ga29 1e-06
RGA29 ga29 0 0.1
LGB29 b29 gb29 1e-06
RGB29 gb29 0 0.1
CA30 a30 a31 1e-09
CB30 b30 b31 1e-09
LGA30 a30 ga30 1e-06
RGA30 ga30 0 0.1
LGB30 b30 gb30 1e-06
RGB30 gb30 0 0.1
CA31 a31 a32 1e-09
CB31 b31 b32 1e-09
LGA31 a31 ga31 1e-06
RGA31 ga31 0 0.1
LGB31 b31 gb31 1e-06
RGB31 gb31 0 0.1
CA32 a32 a33 1e-09
CB32 b32 b33 1e-09
LGA32 a32 ga32 1e-06
RGA32 ga32 0 0.1
LGB32 b32 gb32 1e-06
RGB32 gb32 0 0.1
CA33 a33 a34 1e-09
CB33 b33 b34 1e-09
LGA33 a33 ga33 1e-06
RGA33 ga33 0 0.1
LGB33 b33 gb33 1e-06
RGB33 gb33 0 0.1
CA34 a34 a35 1e-09
CB34 b34 b35 1e-09
LGA34 a34 ga34 1e-06
RGA34 ga34 0 0.1
LGB34 b34 gb34 1e-06
RGB34 gb34 0 0.1
CA35 a35 a36 1e-09
CB35 b35 b36 1e-09
LGA35 a35 ga35 1e-06
RGA35 ga35 0 0.1
LGB35 b35 gb35 1e-06
RGB35 gb35 0 0.1
CA36 a36 a37 1e-09
CB36 b36 b37 1e-09
LGA36 a36 ga36 1e-06
RGA36 ga36 0 0.1
LGB36 b36 gb36 1e-06
RGB36 gb36 0 0.1
CA37 a37 a38 1e-09
CB37 b37 b38 1e-09
LGA37 a37 ga37 1e-06
RGA37 ga37 0 0.1
LGB37 b37 gb37 1e-06
RGB37 gb37 0 0.1
CA38 a38 a39 1e-09
CB38 b38 b39 1e-09
LGA38 a38 ga38 1e-06
RGA38 ga38 0 0.1
LGB38 b38 gb38 1e-06
RGB38 gb38 0 0.1
CA39 a39 a40 1e-09
CB39 b39 b40 1e-09
LGA39 a39 ga39 1e-06
RGA39 ga39 0 0.1
LGB39 b39 gb39 1e-06
RGB39 gb39 0 0.1
CA40 a40 a41 1e-09
CB40 b40 b41 1e-09
LGA40 a40 ga40 1e-06
RGA40 ga40 0 0.1
LGB40 b40 gb40 1e-06
RGB40 gb40 0 0.1
CA41 a41 a42 1e-09
CB41 b41 b42 1e-09
LGA41 a41 ga41 1e-06
RGA41 ga41 0 0.1
LGB41 b41 gb41 1e-06
RGB41 gb41 0 0.1
CA42 a42 a43 1e-09
CB42 b42 b43 1e-09
LGA42 a42 ga42 1e-06
RGA42 ga42 0 0.1
LGB42 b42 gb42 1e-06
RGB42 gb42 0 0.1
CA43 a43 a44 1e-09
CB43 b43 b44 1e-09
LGA43 a43 ga43 1e-06
RGA43 ga43 0 0.1
LGB43 b43 gb43 1e-06
RGB43 gb43 0 0.1
CA44 a44 a45 1e-09
CB44 b44 b45 1e-09
LGA44 a44 ga44 1e-06
RGA44 ga44 0 0.1
LGB44 b44 gb44 1e-06
RGB44 gb44 0 0.1
CA45 a45 a46 1e-09
CB45 b45 b46 1e-09
LGA45 a45 ga45 1e-06
RGA45 ga45 0 0.1
LGB45 b45 gb45 1e-06
RGB45 gb45 0 0.1
CA46 a46 a47 1e-09
CB46 b46 b47 1e-09
LGA46 a46 ga46 1e-06
RGA46 ga46 0 0.1
LGB46 b46 gb46 1e-06
RGB46 gb46 0 0.1
CA47 a47 a48 1e-09
CB47 b47 b48 1e-09
LGA47 a47 ga47 1e-06
RGA47 ga47 0 0.1
LGB47 b47 gb47 1e-06
RGB47 gb47 0 0.1
CA48 a48 a49 1e-09
CB48 b48 b49 1e-09
LGA48 a48 ga48 1e-06
RGA48 ga48 0 0.1
LGB48 b48 gb48 1e-06
RGB48 gb48 0 0.1
CA49 a49 a50 1e-09
CB49 b49 b50 1e-09
LGA49 a49 ga49 1e-06
RGA49 ga49 0 0.1
LGB49 b49 gb49 1e-06
RGB49 gb49 0 0.1
CA50 a50 a51 1e-09
CB50 b50 b51 1e-09
LGA50 a50 ga50 1e-06
RGA50 ga50 0 0.1
LGB50 b50 gb50 1e-06
RGB50 gb50 0 0.1
CA51 a51 a52 1e-09
CB51 b51 b52 1e-09
LGA51 a51 ga51 1e-06
RGA51 ga51 0 0.1
LGB51 b51 gb51 1e-06
RGB51 gb51 0 0.1
CA52 a52 a53 1e-09
CB52 b52 b53 1e-09
LGA52 a52 ga52 1e-06
RGA52 ga52 0 0.1
LGB52 b52 gb52 1e-06
RGB52 gb52 0 0.1
CA53 a53 a54 1e-09
CB53 b53 b54 1e-09
LGA53 a53 ga53 1e-06
RGA53 ga53 0 0.1
LGB53 b53 gb53 1e-06
RGB53 gb53 0 0.1
CA54 a54 a55 1e-09
CB54 b54 b55 1e-09
LGA54 a54 ga54 1e-06
RGA54 ga54 0 0.1
LGB54 b54 gb54 1e-06
RGB54 gb54 0 0.1
CA55 a55 a56 1e-09
CB55 b55 b56 1e-09
LGA55 a55 ga55 1e-06
RGA55 ga55 0 0.1
LGB55 b55 gb55 1e-06
RGB55 gb55 0 0.1
CA56 a56 a57 1e-09
CB56 b56 b57 1e-09
LGA56 a56 ga56 1e-06
RGA56 ga56 0 0.1
LGB56 b56 gb56 1e-06
RGB56 gb56 0 0.1
CA57 a57 a58 1e-09
CB57 b57 b58 1e-09
LGA57 a57 ga57 1e-06
RGA57 ga57 0 0.1
LGB57 b57 gb57 1e-06
RGB57 gb57 0 0.1
CA58 a58 a59 1e-09
CB58 b58 b59 1e-09
LGA58 a58 ga58 1e-06
RGA58 ga58 0 0.1
LGB58 b58 gb58 1e-06
RGB58 gb58 0 0.1
CA59 a59 a60 1e-09
CB59 b59 b60 1e-09
LGA59 a59 ga59 1e-06
RGA59 ga59 0 0.1
LGB59 b59 gb59 1e-06
RGB59 gb59 0 0.1
CA60 a60 a61 1e-09
CB60 b60 b61 1e-09
LGA60 a60 ga60 1e-06
RGA60 ga60 0 0.1
LGB60 b60 gb60 1e-06
RGB60 gb60 0 0.1
CA61 a61 a62 1e-09
CB61 b61 b62 1e-09
LGA61 a61 ga61 1e-06
RGA61 ga61 0 0.1
LGB61 b61 gb61 1e-06
RGB61 gb61 0 0.1
CA62 a62 a63 1e-09
CB62 b62 b63 1e-09
LGA62 a62 ga62 1e-06
RGA62 ga62 0 0.1
LGB62 b62 gb62 1e-06
RGB62 gb62 0 0.1
CA63 a63 a64 1e-09
CB63 b63 b64 1e-09
LGA63 a63 ga63 1e-06
RGA63 ga63 0 0.1
LGB63 b63 gb63 1e-06
RGB63 gb63 0 0.1
CA64 a64 a65 1e-09
CB64 b64 b65 1e-09
LGA64 a64 ga64 1e-06
RGA64 ga64 0 0.1
LGB64 b64 gb64 1e-06
RGB64 gb64 0 0.1
CA65 a65 a66 1e-09
CB65 b65 b66 1e-09
LGA65 a65 ga65 1e-06
RGA65 ga65 0 0.1
LGB65 b65 gb65 1e-06
RGB65 gb65 0 0.1
CA66 a66 a67 1e-09
CB66 b66 b67 1e-09
LGA66 a66 ga66 1e-06
RGA66 ga66 0 0.1
LGB66 b66 gb66 1e-06
RGB66 gb66 0 0.1
CA67 a67 a68 1e-09
CB67 b67 b68 1e-09
LGA67 a67 ga67 1e-06
RGA67 ga67 0 0.1
LGB67 b67 gb67 1e-06
RGB67 gb67 0 0.1
CA68 a68 a69 1e-09
CB68 b68 b69 1e-09
LGA68 a68 ga68 1e-06
RGA68 ga68 0 0.1
LGB68 b68 gb68 1e-06
RGB68 gb68 0 0.1
CA69 a69 a70 1e-09
CB69 b69 b70 1e-09
LGA69 a69 ga69 1e-06
RGA69 ga69 0 0.1
LGB69 b69 gb69 1e-06
RGB69 gb69 0 0.1
CA70 a70 a71 1e-09
CB70 b70 b71 1e-09
LGA70 a70 ga70 1e-06
RGA70 ga70 0 0.1
LGB70 b70 gb70 1e-06
RGB70 gb70 0 0.1
CA71 a71 a72 1e-09
CB71 b71 b72 1e-09
LGA71 a71 ga71 1e-06
RGA71 ga71 0 0.1
LGB71 b71 gb71 1e-06
RGB71 gb71 0 0.1
CA72 a72 a73 1e-09
CB72 b72 b73 1e-09
LGA72 a72 ga72 1e-06
RGA72 ga72 0 0.1
LGB72 b72 gb72 1e-06
RGB72 gb72 0 0.1
CA73 a73 a74 1e-09
CB73 b73 b74 1e-09
LGA73 a73 ga73 1e-06
RGA73 ga73 0 0.1
LGB73 b73 gb73 1e-06
RGB73 gb73 0 0.1
CA74 a74 a75 1e-09
CB74 b74 b75 1e-09
LGA74 a74 ga74 1e-06
RGA74 ga74 0 0.1
LGB74 b74 gb74 1e-06
RGB74 gb74 0 0.1
CA75 a75 a76 1e-09
CB75 b75 b76 1e-09
LGA75 a75 ga75 1e-06
RGA75 ga75 0 0.1
LGB75 b75 gb75 1e-06
RGB75 gb75 0 0.1
CA76 a76 a77 1e-09
CB76 b76 b77 1e-09
LGA76 a76 ga76 1e-06
RGA76 ga76 0 0.1
LGB76 b76 gb76 1e-06
RGB76 gb76 0 0.1
CA77 a77 a78 1e-09
CB77 b77 b78 1e-09
LGA77 a77 ga77 1e-06
RGA77 ga77 0 0.1
LGB77 b77 gb77 1e-06
RGB77 gb77 0 0.1
CA78 a78 a79 1e-09
CB78 b78 b79 1e-09
LGA78 a78 ga78 1e-06
RGA78 ga78 0 0.1
LGB78 b78 gb78 1e-06
RGB78 gb78 0 0.1
CA79 a79 a80 1e-09
CB79 b79 b80 1e-09
LGA79 a79 ga79 1e-06
RGA79 ga79 0 0.1
LGB79 b79 gb79 1e-06
RGB79 gb79 0 0.1
CA80 a80 a81 1e-09
CB80 b80 b81 1e-09
LGA80 a80 ga80 1e-06
RGA80 ga80 0 0.1
LGB80 b80 gb80 1e-06
RGB80 gb80 0 0.1
CA81 a81 a82 1e-09
CB81 b81 b82 1e-09
LGA81 a81 ga81 1e-06
RGA81 ga81 0 0.1
LGB81 b81 gb81 1e-06
RGB81 gb81 0 0.1
CA82 a82 a83 1e-09
CB82 b82 b83 1e-09
LGA82 a82 ga82 1e-06
RGA82 ga82 0 0.1
LGB82 b82 gb82 1e-06
RGB82 gb82 0 0.1
CA83 a83 a84 1e-09
CB83 b83 b84 1e-09
LGA83 a83 ga83 1e-06
RGA83 ga83 0 0.1
LGB83 b83 gb83 1e-06
RGB83 gb83 0 0.1
CA84 a84 a85 1e-09
CB84 b84 b85 1e-09
LGA84 a84 ga84 1e-06
RGA84 ga84 0 0.1
LGB84 b84 gb84 1e-06
RGB84 gb84 0 0.1
CA85 a85 a86 1e-09
CB85 b85 b86 1e-09
LGA85 a85 ga85 1e-06
RGA85 ga85 0 0.1
LGB85 b85 gb85 1e-06
RGB85 gb85 0 0.1
CA86 a86 a87 1e-09
CB86 b86 b87 1e-09
LGA86 a86 ga86 1e-06
RGA86 ga86 0 0.1
LGB86 b86 gb86 1e-06
RGB86 gb86 0 0.1
CA87 a87 a88 1e-09
CB87 b87 b88 1e-09
LGA87 a87 ga87 1e-06
RGA87 ga87 0 0.1
LGB87 b87 gb87 1e-06
RGB87 gb87 0 0.1
CA88 a88 a89 1e-09
CB88 b88 b89 1e-09
LGA88 a88 ga88 1e-06
RGA88 ga88 0 0.1
LGB88 b88 gb88 1e-06
RGB88 gb88 0 0.1
CA89 a89 a90 1e-09
CB89 b89 b90 1e-09
LGA89 a89 ga89 1e-06
RGA89 ga89 0 0.1
LGB89 b89 gb89 1e-06
RGB89 gb89 0 0.1
CA90 a90 a91 1e-09
CB90 b90 b91 1e-09
LGA90 a90 ga90 1e-06
RGA90 ga90 0 0.1
LGB90 b90 gb90 1e-06
RGB90 gb90 0 0.1
CA91 a91 a92 1e-09
CB91 b91 b92 1e-09
LGA91 a91 ga91 1e-06
RGA91 ga91 0 0.1
LGB91 b91 gb91 1e-06
RGB91 gb91 0 0.1
CA92 a92 a93 1e-09
CB92 b92 b93 1e-09
LGA92 a92 ga92 1e-06
RGA92 ga92 0 0.1
LGB92 b92 gb92 1e-06
RGB92 gb92 0 0.1
CA93 a93 a94 1e-09
CB93 b93 b94 1e-09
LGA93 a93 ga93 1e-06
RGA93 ga93 0 0.1
LGB93 b93 gb93 1e-06
RGB93 gb93 0 0.1
CA94 a94 a95 1e-09
CB94 b94 b95 1e-09
LGA94 a94 ga94 1e-06
RGA94 ga94 0 0.1
LGB94 b94 gb94 1e-06
RGB94 gb94 0 0.1
CA95 a95 a96 1e-09
CB95 b95 b96 1e-09
LGA95 a95 ga95 1e-06
RGA95 ga95 0 0.1
LGB95 b95 gb95 1e-06
RGB95 gb95 0 0.1
CA96 a96 a97 1e-09
CB96 b96 b97 1e-09
LGA96 a96 ga96 1e-06
RGA96 ga96 0 0.1
LGB96 b96 gb96 1e-06
RGB96 gb96 0 0.1
CA97 a97 a98 1e-09
CB97 b97 b98 1e-09
LGA97 a97 ga97 1e-06
RGA97 ga97 0 0.1
LGB97 b97 gb97 1e-06
RGB97 gb97 0 0.1
CA98 a98 a99 1e-09
CB98 b98 b99 1e-09
LGA98 a98 ga98 1e-06
RGA98 ga98 0 0.1
LGB98 b98 gb98 1e-06
RGB98 gb98 0 0.1
CA99 a99 b0 1e-09
CB99 b99 a0 1e-09
LGA99 a99 ga99 1e-06
RGA99 ga99 0 0.1
LGB99 b99 gb99 1e-06
RGB99 gb99 0 0.1
IS b0 a0 DC 0 AC 1 0
.ac lin 2001 10meg 200meg
.end
