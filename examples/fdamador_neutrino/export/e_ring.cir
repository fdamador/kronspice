E-ring resonator (fdamador_neutrino)
CS0 n0 m0 6.6406408596000005e-12
LS0 m0 p0 8.983572184450226e-10
RS0 q0 n1 0.2870649963867163
RB0 m0 0 1e+09
RN0 n0 0 1e+09
CS1 n1 m1 6.6406408596000005e-12
LS1 m1 p1 8.983572184450226e-10
RS1 p1 n2 0.2870649963867163
RB1 m1 0 1e+09
RN1 n1 0 1e+09
CS2 n2 m2 6.6406408596000005e-12
LS2 m2 p2 8.983572184450226e-10
RS2 p2 n3 0.2870649963867163
RB2 m2 0 1e+09
RN2 n2 0 1e+09
CS3 n3 m3 6.6406408596000005e-12
LS3 m3 p3 8.983572184450226e-10
RS3 p3 n4 0.2870649963867163
RB3 m3 0 1e+09
RN3 n3 0 1e+09
CS4 n4 m4 6.6406408596000005e-12
LS4 m4 p4 8.983572184450226e-10
RS4 p4 n5 0.2870649963867163
RB4 m4 0 1e+09
RN4 n4 0 1e+09
CS5 n5 m5 6.6406408596000005e-12
LS5 m5 p5 8.983572184450226e-10
RS5 p5 n6 0.2870649963867163
RB5 m5 0 1e+09
RN5 n5 0 1e+09
CS6 n6 m6 6.6406408596000005e-12
LS6 m6 p6 8.983572184450226e-10
RS6 p6 n7 0.2870649963867163
RB6 m6 0 1e+09
RN6 n6 0 1e+09
CS7 n7 m7 6.6406408596000005e-12
LS7 m7 p7 8.983572184450226e-10
RS7 p7 n8 0.2870649963867163
RB7 m7 0 1e+09
RN7 n7 0 1e+09
CS8 n8 m8 6.6406408596000005e-12
LS8 m8 p8 8.983572184450226e-10
RS8 p8 n9 0.2870649963867163
RB8 m8 0 1e+09
RN8 n8 0 1e+09
CS9 n9 m9 6.6406408596000005e-12
LS9 m9 p9 8.983572184450226e-10
RS9 p9 n10 0.2870649963867163
RB9 m9 0 1e+09
RN9 n9 0 1e+09
CS10 n10 m10 6.6406408596000005e-12
LS10 m10 p10 8.983572184450226e-10
RS10 p10 n11 0.2870649963867163
RB10 m10 0 1e+09
RN10 n10 0 1e+09
CS11 n11 m11 6.6406408596000005e-12
LS11 m11 p11 8.983572184450226e-10
RS11 p11 n12 0.2870649963867163
RB11 m11 0 1e+09
RN11 n11 0 1e+09
CS12 n12 m12 6.6406408596000005e-12
LS12 m12 p12 8.983572184450226e-10
RS12 p12 n13 0.2870649963867163
RB12 m12 0 1e+09
RN12 n12 0 1e+09
CS13 n13 m13 6.6406408596000005e-12
LS13 m13 p13 8.983572184450226e-10
RS13 p13 n14 0.2870649963867163
RB13 m13 0 1e+09
RN13 n13 0 1e+09
CS14 n14 m14 6.6406408596000005e-12
LS14 m14 p14 8.983572184450226e-10
RS14 p14 n15 0.2870649963867163
RB14 m14 0 1e+09
RN14 n14 0 1e+09
CS15 n15 m15 6.6406408596000005e-12
LS15 m15 p15 8.983572184450226e-10
RS15 p15 n16 0.2870649963867163
RB15 m15 0 1e+09
RN15 n15 0 1e+09
CS16 n16 m16 6.6406408596000005e-12
LS16 m16 p16 8.983572184450226e-10
RS16 p16 n17 0.2870649963867163
RB16 m16 0 1e+09
RN16 n16 0 1e+09
CS17 n17 m17 6.6406408596000005e-12
LS17 m17 p17 8.983572184450226e-10
RS17 p17 n18 0.2870649963867163
RB17 m17 0 1e+09
RN17 n17 0 1e+09
CS18 n18 m18 6.6406408596000005e-12
LS18 m18 p18 8.983572184450226e-10
RS18 p18 n19 0.2870649963867163
RB18 m18 0 1e+09
RN18 n18 0 1e+09
CS19 n19 m19 6.6406408596000005e-12
LS19 m19 p19 8.983572184450226e-10
RS19 p19 n20 0.2870649963867163
RB19 m19 0 1e+09
RN19 n19 0 1e+09
CS20 n20 m20 6.6406408596000005e-12
LS20 m20 p20 8.983572184450226e-10
RS20 p20 n21 0.2870649963867163
RB20 m20 0 1e+09
RN20 n20 0 1e+09
CS21 n21 m21 6.6406408596000005e-12
LS21 m21 p21 8.983572184450226e-10
RS21 p21 n22 0.2870649963867163
RB21 m21 0 1e+09
RN21 n21 0 1e+09
CS22 n22 m22 6.6406408596000005e-12
LS22 m22 p22 8.983572184450226e-10
RS22 p22 n23 0.2870649963867163
RB22 m22 0 1e+09
RN22 n22 0 1e+09
CS23 n23 m23 6.6406408596000005e-12
LS23 m23 p23 8.983572184450226e-10
RS23 p23 n0 0.2870649963867163
RB23 m23 0 1e+09
RN23 n23 0 1e+09
VS p0 q0 DC 0 AC 1 0
.ac lin 2001 1.9g 2.2g
.end
