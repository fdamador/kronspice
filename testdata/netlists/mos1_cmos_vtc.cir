Level-1 CMOS inverter transfer characteristic
VDD vdd 0 5
VIN in 0 0
MN out in 0 0 nproc L=1u W=10u AD=50p AS=50p PD=30u PS=30u NRD=0.5 NRS=0.5
MP out in vdd vdd pproc L=1u W=25u AD=125p AS=125p PD=60u PS=60u NRD=0.5 NRS=0.5
RL out 0 1meg
.model nproc NMOS(LEVEL=1 TOX=20n NSUB=3e16 UO=550 LD=0.1u LAMBDA=0.03 RSH=20 CGSO=2e-10 CGDO=2e-10 CGBO=1e-10 CJ=4e-4 MJ=0.45 CJSW=3e-10 MJSW=0.3 PB=0.8 JS=1e-4)
.model pproc PMOS(LEVEL=1 TOX=20n NSUB=1e16 UO=200 LD=0.1u LAMBDA=0.05 RSH=40 CGSO=2e-10 CGDO=2e-10 CGBO=1e-10 CJ=5e-4 MJ=0.5 CJSW=3.5e-10 MJSW=0.33 PB=0.85 JS=1e-4)
.dc VIN 0 5 0.05
.end
