Half-wave rectifier with RC filter
V1 in 0 SIN(0 10 1k)
D1 in out dr
R1 out 0 1k
C1 out 0 10u
.model dr D(IS=1e-14 N=1)
.tran 10u 3m 0 2u
.end
