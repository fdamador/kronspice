Level-1 common-source stage: Meyer, overlap and junction capacitances
VDD vdd 0 5
VIN in 0 DC 1.4 AC 1
RG in g 1k
RD vdd d 10k
CL d 0 0.2p
M1 d g 0 0 nproc L=1u W=20u AD=100p AS=100p PD=30u PS=30u NRD=0.5 NRS=0.5
.model nproc NMOS(LEVEL=1 TOX=20n NSUB=3e16 UO=550 LD=0.1u LAMBDA=0.03 RSH=20 CGSO=2e-10 CGDO=2e-10 CGBO=1e-10 CJ=4e-4 MJ=0.45 CJSW=3e-10 MJSW=0.3 PB=0.8 JS=1e-4)
.ac dec 10 1k 10g
.end
