R-2R ladder, four stages
V1 in 0 8
R1 in n1 2k
R2 n1 0 2k
R3 n1 n2 1k
R4 n2 0 2k
R5 n2 n3 1k
R6 n3 0 2k
R7 n3 n4 1k
R8 n4 0 2k
R9 n4 0 2k
.op
.end
