Level-1 MOSFETs from process parameters: body-biased NMOS follower and PMOS source
VDD vdd 0 5
VG g 0 3.2
VB vb 0 -1
M1 vdd g s vb nproc L=2u W=20u AD=100p AS=100p PD=30u PS=30u NRD=1 NRS=1
RS1 s 0 10k
VGP gp 0 3
M2 dp gp vdd vdd pproc L=3u W=30u NRD=1 NRS=1
RL dp 0 5k
.model nproc NMOS(LEVEL=1 TOX=20n NSUB=3e16 UO=550 LD=0.1u LAMBDA=0.03 RSH=20 CGSO=2e-10 CGDO=2e-10 CGBO=1e-10 CJ=4e-4 MJ=0.45 CJSW=3e-10 MJSW=0.3 PB=0.8 JS=1e-4)
.model pproc PMOS(LEVEL=1 TOX=20n NSUB=1e16 UO=200 LD=0.1u LAMBDA=0.05 RSH=40 CGSO=2e-10 CGDO=2e-10 CGBO=1e-10 CJ=5e-4 MJ=0.5 CJSW=3.5e-10 MJSW=0.33 PB=0.85 JS=1e-4)
.op
.end
