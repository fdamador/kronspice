Level-2 CMOS inverter transfer characteristic
VDD vdd 0 5
VIN in 0 0
MN out in 0 0 n2 L=2u W=10u AD=50p AS=50p PD=30u PS=30u NRD=0.5 NRS=0.5
MP out in vdd vdd p2 L=2u W=25u AD=125p AS=125p PD=60u PS=60u NRD=0.5 NRS=0.5
RL out 0 1meg
.model n2 NMOS(LEVEL=2 TOX=25n NSUB=2e16 UO=600 LD=0.15u XJ=0.3u DELTA=1 UCRIT=5e4 UEXP=0.15 NFS=1e11 NEFF=1.5 VMAX=5e4 RSH=20 CGSO=2.5e-10 CGDO=2.5e-10 CGBO=1e-10 CJ=3.5e-4 MJ=0.45 CJSW=3e-10 PB=0.8 JS=1e-4)
.model p2 PMOS(LEVEL=2 TOX=25n NSUB=8e15 UO=220 LD=0.15u XJ=0.3u UCRIT=5e4 UEXP=0.1 NFS=1e11 NEFF=1.5 VMAX=4e4 RSH=40 CGSO=2.5e-10 CGDO=2.5e-10 CGBO=1e-10 CJ=4.5e-4 MJ=0.5 CJSW=3.5e-10 PB=0.85 JS=1e-4)
.dc VIN 0 5 0.05
.end
