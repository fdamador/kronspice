Level-3 CMOS inverter switching a 50 fF load
VDD vdd 0 5
VIN in 0 PULSE(0 5 2n 1n 1n 10n 25n)
MN out in 0 0 n3 L=1u W=10u AD=50p AS=50p PD=30u PS=30u NRD=0.5 NRS=0.5
MP out in vdd vdd p3 L=1u W=25u AD=125p AS=125p PD=60u PS=60u NRD=0.5 NRS=0.5
CL out 0 50f
.model n3 NMOS(LEVEL=3 TOX=20n NSUB=3e16 UO=550 LD=0.1u XJ=0.25u WD=0.05u DELTA=0.5 THETA=0.06 ETA=0.05 KAPPA=0.4 VMAX=1.5e5 NFS=4e11 RSH=20 CGSO=2e-10 CGDO=2e-10 CGBO=1e-10 CJ=4e-4 MJ=0.45 CJSW=3e-10 PB=0.8 JS=1e-4)
.model p3 PMOS(LEVEL=3 TOX=20n NSUB=1e16 UO=200 LD=0.1u XJ=0.25u WD=0.05u DELTA=0.5 THETA=0.08 ETA=0.05 KAPPA=0.5 VMAX=1.2e5 NFS=4e11 RSH=40 CGSO=2e-10 CGDO=2e-10 CGBO=1e-10 CJ=5e-4 MJ=0.5 CJSW=3.5e-10 PB=0.85 JS=1e-4)
* TMAX 0.01n as in mos1_inv_tran.cir (see doc/M9.md).
.tran 0.1n 30n 0 0.01n
.end
